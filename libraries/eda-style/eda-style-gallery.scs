// eda-symbol + eda-style Gallery — 130 visually unique IC schematic symbols across 6 categories
simulator lang=spectre
// @RNL(type="header") { @VERSION("0.3"); @USE-PACKAGE(name="eda-symbol", version="0.1"); @USE-PACKAGE(name="eda-style", version="0.1")}

// ================================================================ std_basic_semiconductors (48 symbols)
subckt std_basic_semiconductors ()
  u_resistor (n1 n2) resistor_cell
  u_variable_resistor (n1 n2) variable_resistor_cell
  u_capacitor (n1 n2) capacitor_cell
  u_variable_capacitor (n1 n2) variable_capacitor_cell
  u_inductor (n1 n2) inductor_cell
  u_variable_inductor (n1 n2) variable_inductor_cell
  u_transformer (n1 n2 n3 n4) transformer_cell
  u_voltage_source (n1 n2) voltage_source_cell
  u_current_source (n1 n2) current_source_cell
  u_battery (n1 n2) battery_cell
  u_vcvs (n1 n2) vcvs_cell
  u_vccs (n1 n2) vccs_cell
  u_cccs (n1 n2) cccs_cell
  u_ccvs (n1 n2) ccvs_cell
  u_vcvs_4term (n1 n2 n3 n4) vcvs_4term_cell
  u_vccs_4term (n1 n2 n3 n4) vccs_4term_cell
  u_switch (n1 n2) switch_cell
  u_closed_switch (n1 n2) closed_switch_cell
  u_externally_controlled_switch (n1 n2 n3) externally_controlled_switch_cell
  u_voltage_controlled_switch (n1 n2 n3 n4) voltage_controlled_switch_cell
  u_spdt_switch_symbol (n1 n2 n3) spdt_switch_symbol_cell
  u_ground_symbol (n1) ground_symbol_cell
  u_supply_symbol (n1) supply_symbol_cell p=1
  u_io_port_symbol (n1) io_port_symbol_cell p=1
  u_behavioral_source (n1 n2) behavioral_source_cell
  u_rf_port (n1 n2) rf_port_cell
  u_transmission_line (n1 n2 n3 n4) transmission_line_cell
  u_rc_line (n1 n2 n3) rc_line_cell
  u_diode (n1 n2) diode_cell
  u_zener_diode (n1 n2) zener_diode_cell
  u_nmos (n1 n2 n3) nmos_cell
  u_nmos_4term (n1 n2 n3 n4) nmos_4term_cell
  u_pmos (n1 n2 n3) pmos_cell
  u_pmos_4term (n1 n2 n3 n4) pmos_4term_cell
  u_depletion_nmos (n1 n2 n3) depletion_nmos_cell
  u_depletion_nmos_4term (n1 n2 n3 n4) depletion_nmos_4term_cell
  u_depletion_pmos (n1 n2 n3) depletion_pmos_cell
  u_depletion_pmos_4term (n1 n2 n3 n4) depletion_pmos_4term_cell
  u_ndmos (n1 n2 n3) ndmos_cell
  u_ndmos_4term (n1 n2 n3 n4) ndmos_4term_cell
  u_pdmos (n1 n2 n3) pdmos_cell
  u_pdmos_4term (n1 n2 n3 n4) pdmos_4term_cell
  u_npn (n1 n2 n3) npn_cell
  u_pnp (n1 n2 n3) pnp_cell
  u_njfet (n1 n2 n3) njfet_cell
  u_pjfet (n1 n2 n3) pjfet_cell
  u_center_tap_inductor (n1 n2 n3) center_tap_inductor_cell
  u_t_coil (n1 n2 n3) t_coil_cell
// @RNL {
//   (0, 4) @TEXT("Standard Basic & Semiconductor Symbols (48 symbols)", size=2.4, bold=true);
//   #u_resistor @SET-SYMBOL $RESISTOR => @PLACE(0, -8);
//   #u_variable_resistor @SET-SYMBOL $VARIABLE_RESISTOR => @PLACE(28, -8);
//   #u_capacitor @SET-SYMBOL $CAPACITOR => @PLACE(56, -8);
//   #u_variable_capacitor @SET-SYMBOL $VARIABLE_CAPACITOR => @PLACE(84, -8);
//   #u_inductor @SET-SYMBOL $INDUCTOR => @PLACE(112, -8);
//   #u_variable_inductor @SET-SYMBOL $VARIABLE_INDUCTOR => @PLACE(140, -8);
//   #u_transformer @SET-SYMBOL $TRANSFORMER => @PLACE(168, -8);
//   #u_voltage_source @SET-SYMBOL $VOLTAGE_SOURCE => @PLACE(196, -8);
//   #u_current_source @SET-SYMBOL $CURRENT_SOURCE => @PLACE(0, -32);
//   #u_battery @SET-SYMBOL $BATTERY => @PLACE(28, -32);
//   #u_vcvs @SET-SYMBOL $VCVS => @PLACE(56, -32);
//   #u_vccs @SET-SYMBOL $VCCS => @PLACE(84, -32);
//   #u_cccs @SET-SYMBOL $CCCS => @PLACE(112, -32);
//   #u_ccvs @SET-SYMBOL $CCVS => @PLACE(140, -32);
//   #u_vcvs_4term @SET-SYMBOL $VCVS_4TERM => @PLACE(168, -32);
//   #u_vccs_4term @SET-SYMBOL $VCCS_4TERM => @PLACE(196, -32);
//   #u_switch @SET-SYMBOL $SWITCH => @PLACE(0, -56);
//   #u_closed_switch @SET-SYMBOL $CLOSED_SWITCH => @PLACE(28, -56);
//   #u_externally_controlled_switch @SET-SYMBOL $EXTERNALLY_CONTROLLED_SWITCH => @PLACE(56, -56);
//   #u_voltage_controlled_switch @SET-SYMBOL $VOLTAGE_CONTROLLED_SWITCH => @PLACE(84, -56);
//   #u_spdt_switch_symbol @SET-SYMBOL $SPDT_SWITCH_SYMBOL => @PLACE(112, -56);
//   #u_ground_symbol @SET-SYMBOL $GROUND_SYMBOL => @PLACE(140, -56);
//   #u_supply_symbol @SET-SYMBOL $SUPPLY_SYMBOL => @PLACE(168, -56);
//   #u_io_port_symbol @SET-SYMBOL $IO_PORT_SYMBOL => @PLACE(196, -56);
//   #u_behavioral_source @SET-SYMBOL $BEHAVIORAL_SOURCE => @PLACE(0, -80);
//   #u_rf_port @SET-SYMBOL $RF_PORT => @PLACE(28, -80);
//   #u_transmission_line @SET-SYMBOL $TRANSMISSION_LINE => @PLACE(56, -80);
//   #u_rc_line @SET-SYMBOL $RC_LINE => @PLACE(84, -80);
//   #u_diode @SET-SYMBOL $DIODE => @PLACE(112, -80);
//   #u_zener_diode @SET-SYMBOL $ZENER_DIODE => @PLACE(140, -80);
//   #u_nmos @SET-SYMBOL $NMOS => @PLACE(168, -80);
//   #u_nmos_4term @SET-SYMBOL $NMOS_4TERM => @PLACE(196, -80);
//   #u_pmos @SET-SYMBOL $PMOS => @PLACE(0, -104);
//   #u_pmos_4term @SET-SYMBOL $PMOS_4TERM => @PLACE(28, -104);
//   #u_depletion_nmos @SET-SYMBOL $DEPLETION_NMOS => @PLACE(56, -104);
//   #u_depletion_nmos_4term @SET-SYMBOL $DEPLETION_NMOS_4TERM => @PLACE(84, -104);
//   #u_depletion_pmos @SET-SYMBOL $DEPLETION_PMOS => @PLACE(112, -104);
//   #u_depletion_pmos_4term @SET-SYMBOL $DEPLETION_PMOS_4TERM => @PLACE(140, -104);
//   #u_ndmos @SET-SYMBOL $NDMOS => @PLACE(168, -104);
//   #u_ndmos_4term @SET-SYMBOL $NDMOS_4TERM => @PLACE(196, -104);
//   #u_pdmos @SET-SYMBOL $PDMOS => @PLACE(0, -128);
//   #u_pdmos_4term @SET-SYMBOL $PDMOS_4TERM => @PLACE(28, -128);
//   #u_npn @SET-SYMBOL $NPN => @PLACE(56, -128);
//   #u_pnp @SET-SYMBOL $PNP => @PLACE(84, -128);
//   #u_njfet @SET-SYMBOL $NJFET => @PLACE(112, -128);
//   #u_pjfet @SET-SYMBOL $PJFET => @PLACE(140, -128);
//   #u_center_tap_inductor @SET-SYMBOL $CENTER_TAP_INDUCTOR => @PLACE(168, -128);
//   #u_t_coil @SET-SYMBOL $T_COIL => @PLACE(196, -128)
// }
ends std_basic_semiconductors

// ================================================================ std_logic_functional (38 symbols)
subckt std_logic_functional ()
  u_opamp (n1 n2 n3) opamp_cell
  u_differential_opamp (n1 n2 n3 n4) differential_opamp_cell
  u_comparator (n1 n2 n3) comparator_cell
  u_voltage_amplifier (n1 n2) voltage_amplifier_cell
  u_transconductor (n1 n2) transconductor_cell
  u_differential_transconductor (n1 n2 n3) differential_transconductor_cell
  u_adc (n1 n2) adc_cell
  u_dac (n1 n2) dac_cell
  u_and_2input (n1 n2 n3) and_2input_cell
  u_and_3input (n1 n2 n3 n4) and_3input_cell
  u_and_4input (n1 n2 n3 n4 n5) and_4input_cell
  u_nand_2input (n1 n2 n3) nand_2input_cell
  u_nand_3input (n1 n2 n3 n4) nand_3input_cell
  u_nand_4input (n1 n2 n3 n4 n5) nand_4input_cell
  u_or_2input (n1 n2 n3) or_2input_cell
  u_or_3input (n1 n2 n3 n4) or_3input_cell
  u_or_4input (n1 n2 n3 n4 n5) or_4input_cell
  u_nor_2input (n1 n2 n3) nor_2input_cell
  u_nor_3input (n1 n2 n3 n4) nor_3input_cell
  u_nor_4input (n1 n2 n3 n4 n5) nor_4input_cell
  u_xor_2input (n1 n2 n3) xor_2input_cell
  u_xor_3input (n1 n2 n3 n4) xor_3input_cell
  u_xor_4input (n1 n2 n3 n4 n5) xor_4input_cell
  u_xnor_2input (n1 n2 n3) xnor_2input_cell
  u_xnor_3input (n1 n2 n3 n4) xnor_3input_cell
  u_xnor_4input (n1 n2 n3 n4 n5) xnor_4input_cell
  u_buffer (n1 n2) buffer_cell
  u_inverter (n1 n2) inverter_cell
  u_d_flip_flop (n1 n2 n3 n4) d_flip_flop_cell
  u_d_flip_flop_q_only (n1 n2 n3) d_flip_flop_q_only_cell
  u_d_flip_flop_with_reset (n1 n2 n3 n4 n5) d_flip_flop_with_reset_cell
  u_delay_cell_symbol (n1 n2) delay_cell_symbol_cell
  u_adder (n1 n2 n3) adder_cell
  u_multiplier (n1 n2 n3) multiplier_cell
  u_integrator_symbol (n1 n2) integrator_symbol_cell
  u_discrete_time_integrator_symbol (n1 n2) discrete_time_integrator_symbol_cell
  u_quantizer_symbol (n1 n2) quantizer_symbol_cell
  u_unit_delay_symbol (n1 n2) unit_delay_symbol_cell
// @RNL {
//   (0, 4) @TEXT("Standard Logic, Functional & Signal-Flow Symbols (38 symbols)", size=2.4, bold=true);
//   #u_opamp @SET-SYMBOL $OPAMP => @PLACE(0, -8);
//   #u_differential_opamp @SET-SYMBOL $DIFFERENTIAL_OPAMP => @PLACE(28, -8);
//   #u_comparator @SET-SYMBOL $COMPARATOR => @PLACE(56, -8);
//   #u_voltage_amplifier @SET-SYMBOL $VOLTAGE_AMPLIFIER => @PLACE(84, -8);
//   #u_transconductor @SET-SYMBOL $TRANSCONDUCTOR => @PLACE(112, -8);
//   #u_differential_transconductor @SET-SYMBOL $DIFFERENTIAL_TRANSCONDUCTOR => @PLACE(140, -8);
//   #u_adc @SET-SYMBOL $ADC => @PLACE(168, -8);
//   #u_dac @SET-SYMBOL $DAC => @PLACE(196, -8);
//   #u_and_2input @SET-SYMBOL $AND_2INPUT => @PLACE(0, -32);
//   #u_and_3input @SET-SYMBOL $AND_3INPUT => @PLACE(28, -32);
//   #u_and_4input @SET-SYMBOL $AND_4INPUT => @PLACE(56, -32);
//   #u_nand_2input @SET-SYMBOL $NAND_2INPUT => @PLACE(84, -32);
//   #u_nand_3input @SET-SYMBOL $NAND_3INPUT => @PLACE(112, -32);
//   #u_nand_4input @SET-SYMBOL $NAND_4INPUT => @PLACE(140, -32);
//   #u_or_2input @SET-SYMBOL $OR_2INPUT => @PLACE(168, -32);
//   #u_or_3input @SET-SYMBOL $OR_3INPUT => @PLACE(196, -32);
//   #u_or_4input @SET-SYMBOL $OR_4INPUT => @PLACE(0, -56);
//   #u_nor_2input @SET-SYMBOL $NOR_2INPUT => @PLACE(28, -56);
//   #u_nor_3input @SET-SYMBOL $NOR_3INPUT => @PLACE(56, -56);
//   #u_nor_4input @SET-SYMBOL $NOR_4INPUT => @PLACE(84, -56);
//   #u_xor_2input @SET-SYMBOL $XOR_2INPUT => @PLACE(112, -56);
//   #u_xor_3input @SET-SYMBOL $XOR_3INPUT => @PLACE(140, -56);
//   #u_xor_4input @SET-SYMBOL $XOR_4INPUT => @PLACE(168, -56);
//   #u_xnor_2input @SET-SYMBOL $XNOR_2INPUT => @PLACE(196, -56);
//   #u_xnor_3input @SET-SYMBOL $XNOR_3INPUT => @PLACE(0, -80);
//   #u_xnor_4input @SET-SYMBOL $XNOR_4INPUT => @PLACE(28, -80);
//   #u_buffer @SET-SYMBOL $BUFFER => @PLACE(56, -80);
//   #u_inverter @SET-SYMBOL $INVERTER => @PLACE(84, -80);
//   #u_d_flip_flop @SET-SYMBOL $D_FLIP_FLOP => @PLACE(112, -80);
//   #u_d_flip_flop_q_only @SET-SYMBOL $D_FLIP_FLOP_Q_ONLY => @PLACE(140, -80);
//   #u_d_flip_flop_with_reset @SET-SYMBOL $D_FLIP_FLOP_WITH_RESET => @PLACE(168, -80);
//   #u_delay_cell_symbol @SET-SYMBOL $DELAY_CELL_SYMBOL => @PLACE(196, -80);
//   #u_adder @SET-SYMBOL $ADDER => @PLACE(0, -104);
//   #u_multiplier @SET-SYMBOL $MULTIPLIER => @PLACE(28, -104);
//   #u_integrator_symbol @SET-SYMBOL $INTEGRATOR_SYMBOL => @PLACE(56, -104);
//   #u_discrete_time_integrator_symbol @SET-SYMBOL $DISCRETE_TIME_INTEGRATOR_SYMBOL => @PLACE(84, -104);
//   #u_quantizer_symbol @SET-SYMBOL $QUANTIZER_SYMBOL => @PLACE(112, -104);
//   #u_unit_delay_symbol @SET-SYMBOL $UNIT_DELAY_SYMBOL => @PLACE(140, -104)
// }
ends std_logic_functional

// ================================================================ passives_sources (12 symbols)
subckt passives_sources ()
  u_vcres (n1 n2 n3 n4) vcres_cell
  u_vccap (n1 n2 n3 n4) vccap_cell
  u_ideal_balun (n1 n2 n3 n4) ideal_balun_cell
  u_vsin (n1 n2) vsin_cell
  u_isin (n1 n2) isin_cell
  u_vpulse (n1 n2) vpulse_cell
  u_ipulse (n1 n2) ipulse_cell
  u_vpwl (n1 n2) vpwl_cell
  u_ipwl (n1 n2) ipwl_cell
  u_vcvsp (n1 n2 n3 n4) vcvsp_cell
  u_vccsp (n1 n2 n3 n4) vccsp_cell
  u_iprobe (n1 n2) iprobe_cell
// @RNL {
//   (0, 4) @TEXT("Universal Passives, Sources & Probes (12 symbols)", size=2.4, bold=true);
//   #u_vcres @SET-SYMBOL $VCRES => @PLACE(0, -8);
//   #u_vccap @SET-SYMBOL $VCCAP => @PLACE(28, -8);
//   #u_ideal_balun @SET-SYMBOL $IDEAL_BALUN => @PLACE(56, -8);
//   #u_vsin @SET-SYMBOL $VSIN => @PLACE(84, -8);
//   #u_isin @SET-SYMBOL $ISIN => @PLACE(112, -8);
//   #u_vpulse @SET-SYMBOL $VPULSE => @PLACE(140, -8);
//   #u_ipulse @SET-SYMBOL $IPULSE => @PLACE(168, -8);
//   #u_vpwl @SET-SYMBOL $VPWL => @PLACE(196, -8);
//   #u_ipwl @SET-SYMBOL $IPWL => @PLACE(0, -32);
//   #u_vcvsp @SET-SYMBOL $VCVSP => @PLACE(28, -32);
//   #u_vccsp @SET-SYMBOL $VCCSP => @PLACE(56, -32);
//   #u_iprobe @SET-SYMBOL $IPROBE => @PLACE(84, -32)
// }
ends passives_sources

// ================================================================ transistors_diodes_switches (7 symbols)
subckt transistors_diodes_switches ()
  u_schottky (n1 n2) schottky_cell
  u_scr (n1 n2 n3 n4) scr_cell
  u_thyristor (n1 n2 n3) thyristor_cell
  u_npn4 (n1 n2 n3 n4) npn4_cell
  u_nmes4 (n1 n2 n3 n4) nmes4_cell
  u_sp3tswitch (n1 n2 n3 n4) sp3tswitch_cell
  u_sp4tswitch (n1 n2 n3 n4 n5) sp4tswitch_cell
// @RNL {
//   (0, 4) @TEXT("Universal Diodes, Transistors, Thyristors & Switches (7 symbols)", size=2.4, bold=true);
//   #u_schottky @SET-SYMBOL $SCHOTTKY => @PLACE(0, -8);
//   #u_scr @SET-SYMBOL $SCR => @PLACE(28, -8);
//   #u_thyristor @SET-SYMBOL $THYRISTOR => @PLACE(56, -8);
//   #u_npn4 @SET-SYMBOL $NPN4 => @PLACE(84, -8);
//   #u_nmes4 @SET-SYMBOL $NMES4 => @PLACE(112, -8);
//   #u_sp3tswitch @SET-SYMBOL $SP3TSWITCH => @PLACE(140, -8);
//   #u_sp4tswitch @SET-SYMBOL $SP4TSWITCH => @PLACE(168, -8)
// }
ends transistors_diodes_switches

// ================================================================ amplifiers_rf_filters (18 symbols)
subckt amplifiers_rf_filters ()
  u_opamp_6term (n1 n2 n3 n4 n5 n6) opamp_6term_cell
  u_deadband_diffamp (n1 n2 n3) deadband_diffamp_cell
  u_limiting_diffamp (n1 n2 n3) limiting_diffamp_cell
  u_vc_vg_diffamp (n1 n2 n3 n4 n5) vc_vg_diffamp_cell
  u_variable_gain_amplifier (n1 n2 n3 n4 n5) variable_gain_amplifier_cell
  u_differentiator (n1 n2) differentiator_cell
  u_divider (n1 n2 n3) divider_cell
  u_subtractor (n1 n2 n3) subtractor_cell
  u_multiplexer (n1 n2 n3 n4 n5 n6) multiplexer_cell
  u_vco (n1 n2 n3) vco_cell
  u_jk_ff (n1 n2 n3 n4 n5) jk_ff_cell
  u_mixer (n1 n2 n3) mixer_cell
  u_osc (n1) osc_cell
  u_quadrature (n1 n2) quadrature_cell
  u_lowpass_filter (n1 n2) lowpass_filter_cell
  u_highpass_filter (n1 n2) highpass_filter_cell
  u_bandpass_filter (n1 n2) bandpass_filter_cell
  u_bandstop_filter (n1 n2) bandstop_filter_cell
// @RNL {
//   (0, 4) @TEXT("Universal Amplifiers, Flip-Flops, RF & Filters (18 symbols)", size=2.4, bold=true);
//   #u_opamp_6term @SET-SYMBOL $OPAMP_6TERM => @PLACE(0, -8);
//   #u_deadband_diffamp @SET-SYMBOL $DEADBAND_DIFFAMP => @PLACE(28, -8);
//   #u_limiting_diffamp @SET-SYMBOL $LIMITING_DIFFAMP => @PLACE(56, -8);
//   #u_vc_vg_diffamp @SET-SYMBOL $VC_VG_DIFFAMP => @PLACE(84, -8);
//   #u_variable_gain_amplifier @SET-SYMBOL $VARIABLE_GAIN_AMPLIFIER => @PLACE(112, -8);
//   #u_differentiator @SET-SYMBOL $DIFFERENTIATOR => @PLACE(140, -8);
//   #u_divider @SET-SYMBOL $DIVIDER => @PLACE(168, -8);
//   #u_subtractor @SET-SYMBOL $SUBTRACTOR => @PLACE(196, -8);
//   #u_multiplexer @SET-SYMBOL $MULTIPLEXER => @PLACE(0, -32);
//   #u_vco @SET-SYMBOL $VCO => @PLACE(28, -32);
//   #u_jk_ff @SET-SYMBOL $JK_FF => @PLACE(56, -32);
//   #u_mixer @SET-SYMBOL $MIXER => @PLACE(84, -32);
//   #u_osc @SET-SYMBOL $OSC => @PLACE(112, -32);
//   #u_quadrature @SET-SYMBOL $QUADRATURE => @PLACE(140, -32);
//   #u_lowpass_filter @SET-SYMBOL $LOWPASS_FILTER => @PLACE(168, -32);
//   #u_highpass_filter @SET-SYMBOL $HIGHPASS_FILTER => @PLACE(196, -32);
//   #u_bandpass_filter @SET-SYMBOL $BANDPASS_FILTER => @PLACE(0, -56);
//   #u_bandstop_filter @SET-SYMBOL $BANDSTOP_FILTER => @PLACE(28, -56)
// }
ends amplifiers_rf_filters

// ================================================================ grounds_supplies_ports (7 symbols)
subckt grounds_supplies_ports ()
  u_cgnd (n1) cgnd_cell
  u_egnd (n1) egnd_cell
  u_vss_symbol (n1) vss_symbol_cell
  u_pwr (n1) pwr_cell
  u_ipin (n1) ipin_cell
  u_opin (n1) opin_cell
  u_on_page_conn (n1) on_page_conn_cell
// @RNL {
//   (0, 4) @TEXT("Universal Grounds, Supplies, Pins & Connectors (7 symbols)", size=2.4, bold=true);
//   #u_cgnd @SET-SYMBOL $CGND => @PLACE(0, -8);
//   #u_egnd @SET-SYMBOL $EGND => @PLACE(28, -8);
//   #u_vss_symbol @SET-SYMBOL $VSS_SYMBOL => @PLACE(56, -8);
//   #u_pwr @SET-SYMBOL $PWR => @PLACE(84, -8);
//   #u_ipin @SET-SYMBOL $IPIN => @PLACE(112, -8);
//   #u_opin @SET-SYMBOL $OPIN => @PLACE(140, -8);
//   #u_on_page_conn @SET-SYMBOL $ON_PAGE_CONN => @PLACE(168, -8)
// }
ends grounds_supplies_ports

// ================================================================ Top-level gallery (130 symbols)
u_resistor (n1 n2) resistor_cell
u_variable_resistor (n1 n2) variable_resistor_cell
u_capacitor (n1 n2) capacitor_cell
u_variable_capacitor (n1 n2) variable_capacitor_cell
u_inductor (n1 n2) inductor_cell
u_variable_inductor (n1 n2) variable_inductor_cell
u_transformer (n1 n2 n3 n4) transformer_cell
u_voltage_source (n1 n2) voltage_source_cell
u_current_source (n1 n2) current_source_cell
u_battery (n1 n2) battery_cell
u_vcvs (n1 n2) vcvs_cell
u_vccs (n1 n2) vccs_cell
u_cccs (n1 n2) cccs_cell
u_ccvs (n1 n2) ccvs_cell
u_vcvs_4term (n1 n2 n3 n4) vcvs_4term_cell
u_vccs_4term (n1 n2 n3 n4) vccs_4term_cell
u_switch (n1 n2) switch_cell
u_closed_switch (n1 n2) closed_switch_cell
u_externally_controlled_switch (n1 n2 n3) externally_controlled_switch_cell
u_voltage_controlled_switch (n1 n2 n3 n4) voltage_controlled_switch_cell
u_spdt_switch_symbol (n1 n2 n3) spdt_switch_symbol_cell
u_ground_symbol (n1) ground_symbol_cell
u_supply_symbol (n1) supply_symbol_cell p=1
u_io_port_symbol (n1) io_port_symbol_cell p=1
u_behavioral_source (n1 n2) behavioral_source_cell
u_rf_port (n1 n2) rf_port_cell
u_transmission_line (n1 n2 n3 n4) transmission_line_cell
u_rc_line (n1 n2 n3) rc_line_cell
u_diode (n1 n2) diode_cell
u_zener_diode (n1 n2) zener_diode_cell
u_nmos (n1 n2 n3) nmos_cell
u_nmos_4term (n1 n2 n3 n4) nmos_4term_cell
u_pmos (n1 n2 n3) pmos_cell
u_pmos_4term (n1 n2 n3 n4) pmos_4term_cell
u_depletion_nmos (n1 n2 n3) depletion_nmos_cell
u_depletion_nmos_4term (n1 n2 n3 n4) depletion_nmos_4term_cell
u_depletion_pmos (n1 n2 n3) depletion_pmos_cell
u_depletion_pmos_4term (n1 n2 n3 n4) depletion_pmos_4term_cell
u_ndmos (n1 n2 n3) ndmos_cell
u_ndmos_4term (n1 n2 n3 n4) ndmos_4term_cell
u_pdmos (n1 n2 n3) pdmos_cell
u_pdmos_4term (n1 n2 n3 n4) pdmos_4term_cell
u_npn (n1 n2 n3) npn_cell
u_pnp (n1 n2 n3) pnp_cell
u_njfet (n1 n2 n3) njfet_cell
u_pjfet (n1 n2 n3) pjfet_cell
u_center_tap_inductor (n1 n2 n3) center_tap_inductor_cell
u_t_coil (n1 n2 n3) t_coil_cell
u_opamp (n1 n2 n3) opamp_cell
u_differential_opamp (n1 n2 n3 n4) differential_opamp_cell
u_comparator (n1 n2 n3) comparator_cell
u_voltage_amplifier (n1 n2) voltage_amplifier_cell
u_transconductor (n1 n2) transconductor_cell
u_differential_transconductor (n1 n2 n3) differential_transconductor_cell
u_adc (n1 n2) adc_cell
u_dac (n1 n2) dac_cell
u_and_2input (n1 n2 n3) and_2input_cell
u_and_3input (n1 n2 n3 n4) and_3input_cell
u_and_4input (n1 n2 n3 n4 n5) and_4input_cell
u_nand_2input (n1 n2 n3) nand_2input_cell
u_nand_3input (n1 n2 n3 n4) nand_3input_cell
u_nand_4input (n1 n2 n3 n4 n5) nand_4input_cell
u_or_2input (n1 n2 n3) or_2input_cell
u_or_3input (n1 n2 n3 n4) or_3input_cell
u_or_4input (n1 n2 n3 n4 n5) or_4input_cell
u_nor_2input (n1 n2 n3) nor_2input_cell
u_nor_3input (n1 n2 n3 n4) nor_3input_cell
u_nor_4input (n1 n2 n3 n4 n5) nor_4input_cell
u_xor_2input (n1 n2 n3) xor_2input_cell
u_xor_3input (n1 n2 n3 n4) xor_3input_cell
u_xor_4input (n1 n2 n3 n4 n5) xor_4input_cell
u_xnor_2input (n1 n2 n3) xnor_2input_cell
u_xnor_3input (n1 n2 n3 n4) xnor_3input_cell
u_xnor_4input (n1 n2 n3 n4 n5) xnor_4input_cell
u_buffer (n1 n2) buffer_cell
u_inverter (n1 n2) inverter_cell
u_d_flip_flop (n1 n2 n3 n4) d_flip_flop_cell
u_d_flip_flop_q_only (n1 n2 n3) d_flip_flop_q_only_cell
u_d_flip_flop_with_reset (n1 n2 n3 n4 n5) d_flip_flop_with_reset_cell
u_delay_cell_symbol (n1 n2) delay_cell_symbol_cell
u_adder (n1 n2 n3) adder_cell
u_multiplier (n1 n2 n3) multiplier_cell
u_integrator_symbol (n1 n2) integrator_symbol_cell
u_discrete_time_integrator_symbol (n1 n2) discrete_time_integrator_symbol_cell
u_quantizer_symbol (n1 n2) quantizer_symbol_cell
u_unit_delay_symbol (n1 n2) unit_delay_symbol_cell
u_vcres (n1 n2 n3 n4) vcres_cell
u_vccap (n1 n2 n3 n4) vccap_cell
u_ideal_balun (n1 n2 n3 n4) ideal_balun_cell
u_vsin (n1 n2) vsin_cell
u_isin (n1 n2) isin_cell
u_vpulse (n1 n2) vpulse_cell
u_ipulse (n1 n2) ipulse_cell
u_vpwl (n1 n2) vpwl_cell
u_ipwl (n1 n2) ipwl_cell
u_vcvsp (n1 n2 n3 n4) vcvsp_cell
u_vccsp (n1 n2 n3 n4) vccsp_cell
u_iprobe (n1 n2) iprobe_cell
u_schottky (n1 n2) schottky_cell
u_scr (n1 n2 n3 n4) scr_cell
u_thyristor (n1 n2 n3) thyristor_cell
u_npn4 (n1 n2 n3 n4) npn4_cell
u_nmes4 (n1 n2 n3 n4) nmes4_cell
u_sp3tswitch (n1 n2 n3 n4) sp3tswitch_cell
u_sp4tswitch (n1 n2 n3 n4 n5) sp4tswitch_cell
u_opamp_6term (n1 n2 n3 n4 n5 n6) opamp_6term_cell
u_deadband_diffamp (n1 n2 n3) deadband_diffamp_cell
u_limiting_diffamp (n1 n2 n3) limiting_diffamp_cell
u_vc_vg_diffamp (n1 n2 n3 n4 n5) vc_vg_diffamp_cell
u_variable_gain_amplifier (n1 n2 n3 n4 n5) variable_gain_amplifier_cell
u_differentiator (n1 n2) differentiator_cell
u_divider (n1 n2 n3) divider_cell
u_subtractor (n1 n2 n3) subtractor_cell
u_multiplexer (n1 n2 n3 n4 n5 n6) multiplexer_cell
u_vco (n1 n2 n3) vco_cell
u_jk_ff (n1 n2 n3 n4 n5) jk_ff_cell
u_mixer (n1 n2 n3) mixer_cell
u_osc (n1) osc_cell
u_quadrature (n1 n2) quadrature_cell
u_lowpass_filter (n1 n2) lowpass_filter_cell
u_highpass_filter (n1 n2) highpass_filter_cell
u_bandpass_filter (n1 n2) bandpass_filter_cell
u_bandstop_filter (n1 n2) bandstop_filter_cell
u_cgnd (n1) cgnd_cell
u_egnd (n1) egnd_cell
u_vss_symbol (n1) vss_symbol_cell
u_pwr (n1) pwr_cell
u_ipin (n1) ipin_cell
u_opin (n1) opin_cell
u_on_page_conn (n1) on_page_conn_cell
// @RNL {
//   (0, 8) @TEXT("eda-style 0.1 — Complete Symbol Gallery (130 unique symbols)", size=3, bold=true);
//   (0, 0) @TEXT("Standard Basic & Semiconductor Symbols (48)", size=2.2, bold=true);
//   #u_resistor @SET-SYMBOL $RESISTOR => @PLACE(0, -10);
//   #u_variable_resistor @SET-SYMBOL $VARIABLE_RESISTOR => @PLACE(28, -10);
//   #u_capacitor @SET-SYMBOL $CAPACITOR => @PLACE(56, -10);
//   #u_variable_capacitor @SET-SYMBOL $VARIABLE_CAPACITOR => @PLACE(84, -10);
//   #u_inductor @SET-SYMBOL $INDUCTOR => @PLACE(112, -10);
//   #u_variable_inductor @SET-SYMBOL $VARIABLE_INDUCTOR => @PLACE(140, -10);
//   #u_transformer @SET-SYMBOL $TRANSFORMER => @PLACE(168, -10);
//   #u_voltage_source @SET-SYMBOL $VOLTAGE_SOURCE => @PLACE(196, -10);
//   #u_current_source @SET-SYMBOL $CURRENT_SOURCE => @PLACE(224, -10);
//   #u_battery @SET-SYMBOL $BATTERY => @PLACE(252, -10);
//   #u_vcvs @SET-SYMBOL $VCVS => @PLACE(280, -10);
//   #u_vccs @SET-SYMBOL $VCCS => @PLACE(308, -10);
//   #u_cccs @SET-SYMBOL $CCCS => @PLACE(0, -34);
//   #u_ccvs @SET-SYMBOL $CCVS => @PLACE(28, -34);
//   #u_vcvs_4term @SET-SYMBOL $VCVS_4TERM => @PLACE(56, -34);
//   #u_vccs_4term @SET-SYMBOL $VCCS_4TERM => @PLACE(84, -34);
//   #u_switch @SET-SYMBOL $SWITCH => @PLACE(112, -34);
//   #u_closed_switch @SET-SYMBOL $CLOSED_SWITCH => @PLACE(140, -34);
//   #u_externally_controlled_switch @SET-SYMBOL $EXTERNALLY_CONTROLLED_SWITCH => @PLACE(168, -34);
//   #u_voltage_controlled_switch @SET-SYMBOL $VOLTAGE_CONTROLLED_SWITCH => @PLACE(196, -34);
//   #u_spdt_switch_symbol @SET-SYMBOL $SPDT_SWITCH_SYMBOL => @PLACE(224, -34);
//   #u_ground_symbol @SET-SYMBOL $GROUND_SYMBOL => @PLACE(252, -34);
//   #u_supply_symbol @SET-SYMBOL $SUPPLY_SYMBOL => @PLACE(280, -34);
//   #u_io_port_symbol @SET-SYMBOL $IO_PORT_SYMBOL => @PLACE(308, -34);
//   #u_behavioral_source @SET-SYMBOL $BEHAVIORAL_SOURCE => @PLACE(0, -58);
//   #u_rf_port @SET-SYMBOL $RF_PORT => @PLACE(28, -58);
//   #u_transmission_line @SET-SYMBOL $TRANSMISSION_LINE => @PLACE(56, -58);
//   #u_rc_line @SET-SYMBOL $RC_LINE => @PLACE(84, -58);
//   #u_diode @SET-SYMBOL $DIODE => @PLACE(112, -58);
//   #u_zener_diode @SET-SYMBOL $ZENER_DIODE => @PLACE(140, -58);
//   #u_nmos @SET-SYMBOL $NMOS => @PLACE(168, -58);
//   #u_nmos_4term @SET-SYMBOL $NMOS_4TERM => @PLACE(196, -58);
//   #u_pmos @SET-SYMBOL $PMOS => @PLACE(224, -58);
//   #u_pmos_4term @SET-SYMBOL $PMOS_4TERM => @PLACE(252, -58);
//   #u_depletion_nmos @SET-SYMBOL $DEPLETION_NMOS => @PLACE(280, -58);
//   #u_depletion_nmos_4term @SET-SYMBOL $DEPLETION_NMOS_4TERM => @PLACE(308, -58);
//   #u_depletion_pmos @SET-SYMBOL $DEPLETION_PMOS => @PLACE(0, -82);
//   #u_depletion_pmos_4term @SET-SYMBOL $DEPLETION_PMOS_4TERM => @PLACE(28, -82);
//   #u_ndmos @SET-SYMBOL $NDMOS => @PLACE(56, -82);
//   #u_ndmos_4term @SET-SYMBOL $NDMOS_4TERM => @PLACE(84, -82);
//   #u_pdmos @SET-SYMBOL $PDMOS => @PLACE(112, -82);
//   #u_pdmos_4term @SET-SYMBOL $PDMOS_4TERM => @PLACE(140, -82);
//   #u_npn @SET-SYMBOL $NPN => @PLACE(168, -82);
//   #u_pnp @SET-SYMBOL $PNP => @PLACE(196, -82);
//   #u_njfet @SET-SYMBOL $NJFET => @PLACE(224, -82);
//   #u_pjfet @SET-SYMBOL $PJFET => @PLACE(252, -82);
//   #u_center_tap_inductor @SET-SYMBOL $CENTER_TAP_INDUCTOR => @PLACE(280, -82);
//   #u_t_coil @SET-SYMBOL $T_COIL => @PLACE(308, -82);
//   (0, -112) @TEXT("Standard Logic, Functional & Signal-Flow Symbols (38)", size=2.2, bold=true);
//   #u_opamp @SET-SYMBOL $OPAMP => @PLACE(0, -122);
//   #u_differential_opamp @SET-SYMBOL $DIFFERENTIAL_OPAMP => @PLACE(28, -122);
//   #u_comparator @SET-SYMBOL $COMPARATOR => @PLACE(56, -122);
//   #u_voltage_amplifier @SET-SYMBOL $VOLTAGE_AMPLIFIER => @PLACE(84, -122);
//   #u_transconductor @SET-SYMBOL $TRANSCONDUCTOR => @PLACE(112, -122);
//   #u_differential_transconductor @SET-SYMBOL $DIFFERENTIAL_TRANSCONDUCTOR => @PLACE(140, -122);
//   #u_adc @SET-SYMBOL $ADC => @PLACE(168, -122);
//   #u_dac @SET-SYMBOL $DAC => @PLACE(196, -122);
//   #u_and_2input @SET-SYMBOL $AND_2INPUT => @PLACE(224, -122);
//   #u_and_3input @SET-SYMBOL $AND_3INPUT => @PLACE(252, -122);
//   #u_and_4input @SET-SYMBOL $AND_4INPUT => @PLACE(280, -122);
//   #u_nand_2input @SET-SYMBOL $NAND_2INPUT => @PLACE(308, -122);
//   #u_nand_3input @SET-SYMBOL $NAND_3INPUT => @PLACE(0, -146);
//   #u_nand_4input @SET-SYMBOL $NAND_4INPUT => @PLACE(28, -146);
//   #u_or_2input @SET-SYMBOL $OR_2INPUT => @PLACE(56, -146);
//   #u_or_3input @SET-SYMBOL $OR_3INPUT => @PLACE(84, -146);
//   #u_or_4input @SET-SYMBOL $OR_4INPUT => @PLACE(112, -146);
//   #u_nor_2input @SET-SYMBOL $NOR_2INPUT => @PLACE(140, -146);
//   #u_nor_3input @SET-SYMBOL $NOR_3INPUT => @PLACE(168, -146);
//   #u_nor_4input @SET-SYMBOL $NOR_4INPUT => @PLACE(196, -146);
//   #u_xor_2input @SET-SYMBOL $XOR_2INPUT => @PLACE(224, -146);
//   #u_xor_3input @SET-SYMBOL $XOR_3INPUT => @PLACE(252, -146);
//   #u_xor_4input @SET-SYMBOL $XOR_4INPUT => @PLACE(280, -146);
//   #u_xnor_2input @SET-SYMBOL $XNOR_2INPUT => @PLACE(308, -146);
//   #u_xnor_3input @SET-SYMBOL $XNOR_3INPUT => @PLACE(0, -170);
//   #u_xnor_4input @SET-SYMBOL $XNOR_4INPUT => @PLACE(28, -170);
//   #u_buffer @SET-SYMBOL $BUFFER => @PLACE(56, -170);
//   #u_inverter @SET-SYMBOL $INVERTER => @PLACE(84, -170);
//   #u_d_flip_flop @SET-SYMBOL $D_FLIP_FLOP => @PLACE(112, -170);
//   #u_d_flip_flop_q_only @SET-SYMBOL $D_FLIP_FLOP_Q_ONLY => @PLACE(140, -170);
//   #u_d_flip_flop_with_reset @SET-SYMBOL $D_FLIP_FLOP_WITH_RESET => @PLACE(168, -170);
//   #u_delay_cell_symbol @SET-SYMBOL $DELAY_CELL_SYMBOL => @PLACE(196, -170);
//   #u_adder @SET-SYMBOL $ADDER => @PLACE(224, -170);
//   #u_multiplier @SET-SYMBOL $MULTIPLIER => @PLACE(252, -170);
//   #u_integrator_symbol @SET-SYMBOL $INTEGRATOR_SYMBOL => @PLACE(280, -170);
//   #u_discrete_time_integrator_symbol @SET-SYMBOL $DISCRETE_TIME_INTEGRATOR_SYMBOL => @PLACE(308, -170);
//   #u_quantizer_symbol @SET-SYMBOL $QUANTIZER_SYMBOL => @PLACE(0, -194);
//   #u_unit_delay_symbol @SET-SYMBOL $UNIT_DELAY_SYMBOL => @PLACE(28, -194);
//   (0, -224) @TEXT("Universal Passives, Sources & Probes (12)", size=2.2, bold=true);
//   #u_vcres @SET-SYMBOL $VCRES => @PLACE(0, -234);
//   #u_vccap @SET-SYMBOL $VCCAP => @PLACE(28, -234);
//   #u_ideal_balun @SET-SYMBOL $IDEAL_BALUN => @PLACE(56, -234);
//   #u_vsin @SET-SYMBOL $VSIN => @PLACE(84, -234);
//   #u_isin @SET-SYMBOL $ISIN => @PLACE(112, -234);
//   #u_vpulse @SET-SYMBOL $VPULSE => @PLACE(140, -234);
//   #u_ipulse @SET-SYMBOL $IPULSE => @PLACE(168, -234);
//   #u_vpwl @SET-SYMBOL $VPWL => @PLACE(196, -234);
//   #u_ipwl @SET-SYMBOL $IPWL => @PLACE(224, -234);
//   #u_vcvsp @SET-SYMBOL $VCVSP => @PLACE(252, -234);
//   #u_vccsp @SET-SYMBOL $VCCSP => @PLACE(280, -234);
//   #u_iprobe @SET-SYMBOL $IPROBE => @PLACE(308, -234);
//   (0, -264) @TEXT("Universal Diodes, Transistors, Thyristors & Switches (7)", size=2.2, bold=true);
//   #u_schottky @SET-SYMBOL $SCHOTTKY => @PLACE(0, -274);
//   #u_scr @SET-SYMBOL $SCR => @PLACE(28, -274);
//   #u_thyristor @SET-SYMBOL $THYRISTOR => @PLACE(56, -274);
//   #u_npn4 @SET-SYMBOL $NPN4 => @PLACE(84, -274);
//   #u_nmes4 @SET-SYMBOL $NMES4 => @PLACE(112, -274);
//   #u_sp3tswitch @SET-SYMBOL $SP3TSWITCH => @PLACE(140, -274);
//   #u_sp4tswitch @SET-SYMBOL $SP4TSWITCH => @PLACE(168, -274);
//   (0, -304) @TEXT("Universal Amplifiers, Flip-Flops, RF & Filters (18)", size=2.2, bold=true);
//   #u_opamp_6term @SET-SYMBOL $OPAMP_6TERM => @PLACE(0, -314);
//   #u_deadband_diffamp @SET-SYMBOL $DEADBAND_DIFFAMP => @PLACE(28, -314);
//   #u_limiting_diffamp @SET-SYMBOL $LIMITING_DIFFAMP => @PLACE(56, -314);
//   #u_vc_vg_diffamp @SET-SYMBOL $VC_VG_DIFFAMP => @PLACE(84, -314);
//   #u_variable_gain_amplifier @SET-SYMBOL $VARIABLE_GAIN_AMPLIFIER => @PLACE(112, -314);
//   #u_differentiator @SET-SYMBOL $DIFFERENTIATOR => @PLACE(140, -314);
//   #u_divider @SET-SYMBOL $DIVIDER => @PLACE(168, -314);
//   #u_subtractor @SET-SYMBOL $SUBTRACTOR => @PLACE(196, -314);
//   #u_multiplexer @SET-SYMBOL $MULTIPLEXER => @PLACE(224, -314);
//   #u_vco @SET-SYMBOL $VCO => @PLACE(252, -314);
//   #u_jk_ff @SET-SYMBOL $JK_FF => @PLACE(280, -314);
//   #u_mixer @SET-SYMBOL $MIXER => @PLACE(308, -314);
//   #u_osc @SET-SYMBOL $OSC => @PLACE(0, -338);
//   #u_quadrature @SET-SYMBOL $QUADRATURE => @PLACE(28, -338);
//   #u_lowpass_filter @SET-SYMBOL $LOWPASS_FILTER => @PLACE(56, -338);
//   #u_highpass_filter @SET-SYMBOL $HIGHPASS_FILTER => @PLACE(84, -338);
//   #u_bandpass_filter @SET-SYMBOL $BANDPASS_FILTER => @PLACE(112, -338);
//   #u_bandstop_filter @SET-SYMBOL $BANDSTOP_FILTER => @PLACE(140, -338);
//   (0, -368) @TEXT("Universal Grounds, Supplies, Pins & Connectors (7)", size=2.2, bold=true);
//   #u_cgnd @SET-SYMBOL $CGND => @PLACE(0, -378);
//   #u_egnd @SET-SYMBOL $EGND => @PLACE(28, -378);
//   #u_vss_symbol @SET-SYMBOL $VSS_SYMBOL => @PLACE(56, -378);
//   #u_pwr @SET-SYMBOL $PWR => @PLACE(84, -378);
//   #u_ipin @SET-SYMBOL $IPIN => @PLACE(112, -378);
//   #u_opin @SET-SYMBOL $OPIN => @PLACE(140, -378);
//   #u_on_page_conn @SET-SYMBOL $ON_PAGE_CONN => @PLACE(168, -378)
// }
