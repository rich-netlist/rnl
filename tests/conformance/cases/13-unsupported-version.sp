* A file written for a language version this tool does not support
*! 16.1：声明的大版本不受支持，整个文件的 RNL 不解释、原样保留；宿主网表照常读，图由查看器按自己的默认画。
R1 a b 1k
C1 b 0 1p
* @RNL(type="header") { @VERSION("9.0")}
* @RNL { #R1 @PLACE(0, 0) => @FUTURE_KEYWORD(x=1)}
.end
