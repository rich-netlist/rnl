// A standard series without rule packages drops nothing
*! 用工具自带的标准包 0.2：这个系列没有方言的规则包，0.3 版的文件也就什么都不去掉（16.3）；I0 照 0.2 的规则按名字画成电流源。
simulator lang=spectre
// @RNL(type="header") { @VERSION("0.3")}
subckt cell (p n)
ends cell
I0 (a 0) cell
R0 (a 0) resistor r=1k
// @RNL { #I0 @PLACE(0, 0); #R0 @PLACE(10, 0) }
