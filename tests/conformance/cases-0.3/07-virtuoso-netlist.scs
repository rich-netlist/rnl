// A netlist as Virtuoso writes it: the instances of subcircuits are named I0, I1 and so on
*! A Spectre netlist exported by Virtuoso, where the instances of subcircuits are named I0 and I1 (16.3): a file of version 0.3 does not use the SPICE rule package, so they are drawn as subcircuit boxes, not as current sources; the real current source I2 is drawn by its master isource.
*! The header record comes after simulator lang=spectre and is written with // (16.3). M0 and M1 in the subcircuit inv are drawn as P- and N-type MOS by model type.
simulator lang=spectre
// @RNL(type="header") { @VERSION("0.3")}
global 0 vdd!
subckt inv in out
    M0 (out in vdd! vdd!) pmos4 w=2u l=180n
    M1 (out in 0 0) nmos4 w=1u l=180n
// @RNL { #M0 @PLACE(0, 4); #M1 @PLACE(0, -4) }
ends inv
I0 (a b) inv
I1 (b c) inv
I2 (vdd! a) isource dc=10u
V0 (vdd! 0) vsource dc=1.8
model pmos4 bsim4 type=p
model nmos4 bsim4 type=n
// @RNL { #I0 @PLACE(0, 0); #I1 @PLACE(10, 0); #I2 @PLACE(-6, 4); #V0 @PLACE(-12, 0) }
