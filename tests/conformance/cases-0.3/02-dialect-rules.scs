// The rule package of the other dialect, dropped by the dialect of each file
*! A file of version 0.3 does not use the rule package of the other dialect (16.3): this .scs file is in the Spectre dialect and does not use rnl-std-spice; the 02-dialect-rules-sp.inc it includes is in the SPICE dialect and does not use rnl-std-spectre.
*! The standard packages are the 0.3 series that comes with the tool: a file of version 0.3 uses it implicitly (16.3). rnl-std-spice gives R* and I* their symbols by element letter, rnl-std-spectre gives resistor and isource theirs by master.
*! I0 is an instance of the subcircuit cell, a name Virtuoso often gives; with the SPICE rule package left out, it is no longer drawn as a current source. R0 is drawn as a resistor by its master.
*! A simulator lang=spice in the middle of the file does not change the file's dialect: the current source I3 written in SPICE in the subcircuit mid is not drawn by the SPICE rules (element letter) either: the adapter gives it the corresponding Spectre master isource, so the Spectre rules draw it as a current source. I1 and R1 in spsub are drawn by the SPICE rules.
simulator lang=spectre
// @RNL(type="header") { @VERSION("0.3")}
subckt cell (p n)
ends cell
I0 (a 0) cell
R0 (a 0) resistor r=1k
include "02-dialect-rules-sp.inc"
simulator lang=spice
.subckt mid a b
I3 a b 1m
* @RNL { #I3 @PLACE(0, 0) }
.ends
simulator lang=spectre
// @RNL { #I0 @PLACE(0, 0); #R0 @PLACE(10, 0) }
