* Synthetic star; n=64; generated by prepare_inputs.py
* @RNL(type="header") { @VERSION("0.3") }
R0 hub leaf0 1k
R1 hub leaf1 1k
R2 hub leaf2 1k
R3 hub leaf3 1k
R4 hub leaf4 1k
R5 hub leaf5 1k
R6 hub leaf6 1k
R7 hub leaf7 1k
R8 hub leaf8 1k
R9 hub leaf9 1k
R10 hub leaf10 1k
R11 hub leaf11 1k
R12 hub leaf12 1k
R13 hub leaf13 1k
R14 hub leaf14 1k
R15 hub leaf15 1k
R16 hub leaf16 1k
R17 hub leaf17 1k
R18 hub leaf18 1k
R19 hub leaf19 1k
R20 hub leaf20 1k
R21 hub leaf21 1k
R22 hub leaf22 1k
R23 hub leaf23 1k
R24 hub leaf24 1k
R25 hub leaf25 1k
R26 hub leaf26 1k
R27 hub leaf27 1k
R28 hub leaf28 1k
R29 hub leaf29 1k
R30 hub leaf30 1k
R31 hub leaf31 1k
R32 hub leaf32 1k
R33 hub leaf33 1k
R34 hub leaf34 1k
R35 hub leaf35 1k
R36 hub leaf36 1k
R37 hub leaf37 1k
R38 hub leaf38 1k
R39 hub leaf39 1k
R40 hub leaf40 1k
R41 hub leaf41 1k
R42 hub leaf42 1k
R43 hub leaf43 1k
R44 hub leaf44 1k
R45 hub leaf45 1k
R46 hub leaf46 1k
R47 hub leaf47 1k
R48 hub leaf48 1k
R49 hub leaf49 1k
R50 hub leaf50 1k
R51 hub leaf51 1k
R52 hub leaf52 1k
R53 hub leaf53 1k
R54 hub leaf54 1k
R55 hub leaf55 1k
R56 hub leaf56 1k
R57 hub leaf57 1k
R58 hub leaf58 1k
R59 hub leaf59 1k
R60 hub leaf60 1k
R61 hub leaf61 1k
R62 hub leaf62 1k
R63 hub leaf63 1k
* @RNL {
*   {#R0 #R1 #R2 #R3 #R4 #R5 #R6 #R7 #R8 #R9 #R10 #R11 #R12 #R13 #R14 #R15 #R16 #R17 #R18 #R19 #R20 #R21 #R22 #R23 #R24 #R25 #R26 #R27 #R28 #R29 #R30 #R31 #R32 #R33 #R34 #R35 #R36 #R37 #R38 #R39 #R40 #R41 #R42 #R43 #R44 #R45 #R46 #R47 #R48 #R49 #R50 #R51 #R52 #R53 #R54 #R55 #R56 #R57 #R58 #R59 #R60 #R61 #R62 #R63} @ALIGN("y");
*   {#R0 #R1 #R2 #R3 #R4 #R5 #R6 #R7 #R8 #R9 #R10 #R11 #R12 #R13 #R14 #R15 #R16 #R17 #R18 #R19 #R20 #R21 #R22 #R23 #R24 #R25 #R26 #R27 #R28 #R29 #R30 #R31 #R32 #R33 #R34 #R35 #R36 #R37 #R38 #R39 #R40 #R41 #R42 #R43 #R44 #R45 #R46 #R47 #R48 #R49 #R50 #R51 #R52 #R53 #R54 #R55 #R56 #R57 #R58 #R59 #R60 #R61 #R62 #R63} @ORDER("left-to-right");
*   $WIRE_NET_SET @ROUTE
* }
.end
