* Synthetic star; n=32; generated by prepare_inputs.py
* @RNL(type="header") { @VERSION("0.3") }
R0 hub leaf0 1k
R1 hub leaf1 1k
R2 hub leaf2 1k
R3 hub leaf3 1k
R4 hub leaf4 1k
R5 hub leaf5 1k
R6 hub leaf6 1k
R7 hub leaf7 1k
R8 hub leaf8 1k
R9 hub leaf9 1k
R10 hub leaf10 1k
R11 hub leaf11 1k
R12 hub leaf12 1k
R13 hub leaf13 1k
R14 hub leaf14 1k
R15 hub leaf15 1k
R16 hub leaf16 1k
R17 hub leaf17 1k
R18 hub leaf18 1k
R19 hub leaf19 1k
R20 hub leaf20 1k
R21 hub leaf21 1k
R22 hub leaf22 1k
R23 hub leaf23 1k
R24 hub leaf24 1k
R25 hub leaf25 1k
R26 hub leaf26 1k
R27 hub leaf27 1k
R28 hub leaf28 1k
R29 hub leaf29 1k
R30 hub leaf30 1k
R31 hub leaf31 1k
* @RNL {
*   {#R0 #R1 #R2 #R3 #R4 #R5 #R6 #R7 #R8 #R9 #R10 #R11 #R12 #R13 #R14 #R15 #R16 #R17 #R18 #R19 #R20 #R21 #R22 #R23 #R24 #R25 #R26 #R27 #R28 #R29 #R30 #R31} @ALIGN("y");
*   {#R0 #R1 #R2 #R3 #R4 #R5 #R6 #R7 #R8 #R9 #R10 #R11 #R12 #R13 #R14 #R15 #R16 #R17 #R18 #R19 #R20 #R21 #R22 #R23 #R24 #R25 #R26 #R27 #R28 #R29 #R30 #R31} @ORDER("left-to-right");
*   $WIRE_NET_SET @ROUTE
* }
.end
