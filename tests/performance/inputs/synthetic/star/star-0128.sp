* Synthetic star; n=128; generated by prepare_inputs.py
* @RNL(type="header") { @VERSION("0.3") }
R0 hub leaf0 1k
R1 hub leaf1 1k
R2 hub leaf2 1k
R3 hub leaf3 1k
R4 hub leaf4 1k
R5 hub leaf5 1k
R6 hub leaf6 1k
R7 hub leaf7 1k
R8 hub leaf8 1k
R9 hub leaf9 1k
R10 hub leaf10 1k
R11 hub leaf11 1k
R12 hub leaf12 1k
R13 hub leaf13 1k
R14 hub leaf14 1k
R15 hub leaf15 1k
R16 hub leaf16 1k
R17 hub leaf17 1k
R18 hub leaf18 1k
R19 hub leaf19 1k
R20 hub leaf20 1k
R21 hub leaf21 1k
R22 hub leaf22 1k
R23 hub leaf23 1k
R24 hub leaf24 1k
R25 hub leaf25 1k
R26 hub leaf26 1k
R27 hub leaf27 1k
R28 hub leaf28 1k
R29 hub leaf29 1k
R30 hub leaf30 1k
R31 hub leaf31 1k
R32 hub leaf32 1k
R33 hub leaf33 1k
R34 hub leaf34 1k
R35 hub leaf35 1k
R36 hub leaf36 1k
R37 hub leaf37 1k
R38 hub leaf38 1k
R39 hub leaf39 1k
R40 hub leaf40 1k
R41 hub leaf41 1k
R42 hub leaf42 1k
R43 hub leaf43 1k
R44 hub leaf44 1k
R45 hub leaf45 1k
R46 hub leaf46 1k
R47 hub leaf47 1k
R48 hub leaf48 1k
R49 hub leaf49 1k
R50 hub leaf50 1k
R51 hub leaf51 1k
R52 hub leaf52 1k
R53 hub leaf53 1k
R54 hub leaf54 1k
R55 hub leaf55 1k
R56 hub leaf56 1k
R57 hub leaf57 1k
R58 hub leaf58 1k
R59 hub leaf59 1k
R60 hub leaf60 1k
R61 hub leaf61 1k
R62 hub leaf62 1k
R63 hub leaf63 1k
R64 hub leaf64 1k
R65 hub leaf65 1k
R66 hub leaf66 1k
R67 hub leaf67 1k
R68 hub leaf68 1k
R69 hub leaf69 1k
R70 hub leaf70 1k
R71 hub leaf71 1k
R72 hub leaf72 1k
R73 hub leaf73 1k
R74 hub leaf74 1k
R75 hub leaf75 1k
R76 hub leaf76 1k
R77 hub leaf77 1k
R78 hub leaf78 1k
R79 hub leaf79 1k
R80 hub leaf80 1k
R81 hub leaf81 1k
R82 hub leaf82 1k
R83 hub leaf83 1k
R84 hub leaf84 1k
R85 hub leaf85 1k
R86 hub leaf86 1k
R87 hub leaf87 1k
R88 hub leaf88 1k
R89 hub leaf89 1k
R90 hub leaf90 1k
R91 hub leaf91 1k
R92 hub leaf92 1k
R93 hub leaf93 1k
R94 hub leaf94 1k
R95 hub leaf95 1k
R96 hub leaf96 1k
R97 hub leaf97 1k
R98 hub leaf98 1k
R99 hub leaf99 1k
R100 hub leaf100 1k
R101 hub leaf101 1k
R102 hub leaf102 1k
R103 hub leaf103 1k
R104 hub leaf104 1k
R105 hub leaf105 1k
R106 hub leaf106 1k
R107 hub leaf107 1k
R108 hub leaf108 1k
R109 hub leaf109 1k
R110 hub leaf110 1k
R111 hub leaf111 1k
R112 hub leaf112 1k
R113 hub leaf113 1k
R114 hub leaf114 1k
R115 hub leaf115 1k
R116 hub leaf116 1k
R117 hub leaf117 1k
R118 hub leaf118 1k
R119 hub leaf119 1k
R120 hub leaf120 1k
R121 hub leaf121 1k
R122 hub leaf122 1k
R123 hub leaf123 1k
R124 hub leaf124 1k
R125 hub leaf125 1k
R126 hub leaf126 1k
R127 hub leaf127 1k
* @RNL {
*   {#R0 #R1 #R2 #R3 #R4 #R5 #R6 #R7 #R8 #R9 #R10 #R11 #R12 #R13 #R14 #R15 #R16 #R17 #R18 #R19 #R20 #R21 #R22 #R23 #R24 #R25 #R26 #R27 #R28 #R29 #R30 #R31 #R32 #R33 #R34 #R35 #R36 #R37 #R38 #R39 #R40 #R41 #R42 #R43 #R44 #R45 #R46 #R47 #R48 #R49 #R50 #R51 #R52 #R53 #R54 #R55 #R56 #R57 #R58 #R59 #R60 #R61 #R62 #R63 #R64 #R65 #R66 #R67 #R68 #R69 #R70 #R71 #R72 #R73 #R74 #R75 #R76 #R77 #R78 #R79 #R80 #R81 #R82 #R83 #R84 #R85 #R86 #R87 #R88 #R89 #R90 #R91 #R92 #R93 #R94 #R95 #R96 #R97 #R98 #R99 #R100 #R101 #R102 #R103 #R104 #R105 #R106 #R107 #R108 #R109 #R110 #R111 #R112 #R113 #R114 #R115 #R116 #R117 #R118 #R119 #R120 #R121 #R122 #R123 #R124 #R125 #R126 #R127} @ALIGN("y");
*   {#R0 #R1 #R2 #R3 #R4 #R5 #R6 #R7 #R8 #R9 #R10 #R11 #R12 #R13 #R14 #R15 #R16 #R17 #R18 #R19 #R20 #R21 #R22 #R23 #R24 #R25 #R26 #R27 #R28 #R29 #R30 #R31 #R32 #R33 #R34 #R35 #R36 #R37 #R38 #R39 #R40 #R41 #R42 #R43 #R44 #R45 #R46 #R47 #R48 #R49 #R50 #R51 #R52 #R53 #R54 #R55 #R56 #R57 #R58 #R59 #R60 #R61 #R62 #R63 #R64 #R65 #R66 #R67 #R68 #R69 #R70 #R71 #R72 #R73 #R74 #R75 #R76 #R77 #R78 #R79 #R80 #R81 #R82 #R83 #R84 #R85 #R86 #R87 #R88 #R89 #R90 #R91 #R92 #R93 #R94 #R95 #R96 #R97 #R98 #R99 #R100 #R101 #R102 #R103 #R104 #R105 #R106 #R107 #R108 #R109 #R110 #R111 #R112 #R113 #R114 #R115 #R116 #R117 #R118 #R119 #R120 #R121 #R122 #R123 #R124 #R125 #R126 #R127} @ORDER("left-to-right");
*   $WIRE_NET_SET @ROUTE
* }
.end
