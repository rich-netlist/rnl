* Synthetic star; n=2; generated by prepare_inputs.py
* @RNL(type="header") { @VERSION("0.3") }
R0 hub leaf0 1k
R1 hub leaf1 1k
* @RNL {
*   {#R0 #R1} @ALIGN("y");
*   {#R0 #R1} @ORDER("left-to-right");
*   $WIRE_NET_SET @ROUTE
* }
.end
