* Synthetic star; n=16; generated by prepare_inputs.py
* @RNL(type="header") { @VERSION("0.3") }
R0 hub leaf0 1k
R1 hub leaf1 1k
R2 hub leaf2 1k
R3 hub leaf3 1k
R4 hub leaf4 1k
R5 hub leaf5 1k
R6 hub leaf6 1k
R7 hub leaf7 1k
R8 hub leaf8 1k
R9 hub leaf9 1k
R10 hub leaf10 1k
R11 hub leaf11 1k
R12 hub leaf12 1k
R13 hub leaf13 1k
R14 hub leaf14 1k
R15 hub leaf15 1k
* @RNL {
*   {#R0 #R1 #R2 #R3 #R4 #R5 #R6 #R7 #R8 #R9 #R10 #R11 #R12 #R13 #R14 #R15} @ALIGN("y");
*   {#R0 #R1 #R2 #R3 #R4 #R5 #R6 #R7 #R8 #R9 #R10 #R11 #R12 #R13 #R14 #R15} @ORDER("left-to-right");
*   $WIRE_NET_SET @ROUTE
* }
.end
