* Synthetic star; n=4; generated by prepare_inputs.py
* @RNL(type="header") { @VERSION("0.3") }
R0 hub leaf0 1k
R1 hub leaf1 1k
R2 hub leaf2 1k
R3 hub leaf3 1k
* @RNL {
*   {#R0 #R1 #R2 #R3} @ALIGN("y");
*   {#R0 #R1 #R2 #R3} @ORDER("left-to-right");
*   $WIRE_NET_SET @ROUTE
* }
.end
