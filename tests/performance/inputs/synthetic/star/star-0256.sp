* Synthetic star; n=256; generated by prepare_inputs.py
* @RNL(type="header") { @VERSION("0.3") }
R0 hub leaf0 1k
R1 hub leaf1 1k
R2 hub leaf2 1k
R3 hub leaf3 1k
R4 hub leaf4 1k
R5 hub leaf5 1k
R6 hub leaf6 1k
R7 hub leaf7 1k
R8 hub leaf8 1k
R9 hub leaf9 1k
R10 hub leaf10 1k
R11 hub leaf11 1k
R12 hub leaf12 1k
R13 hub leaf13 1k
R14 hub leaf14 1k
R15 hub leaf15 1k
R16 hub leaf16 1k
R17 hub leaf17 1k
R18 hub leaf18 1k
R19 hub leaf19 1k
R20 hub leaf20 1k
R21 hub leaf21 1k
R22 hub leaf22 1k
R23 hub leaf23 1k
R24 hub leaf24 1k
R25 hub leaf25 1k
R26 hub leaf26 1k
R27 hub leaf27 1k
R28 hub leaf28 1k
R29 hub leaf29 1k
R30 hub leaf30 1k
R31 hub leaf31 1k
R32 hub leaf32 1k
R33 hub leaf33 1k
R34 hub leaf34 1k
R35 hub leaf35 1k
R36 hub leaf36 1k
R37 hub leaf37 1k
R38 hub leaf38 1k
R39 hub leaf39 1k
R40 hub leaf40 1k
R41 hub leaf41 1k
R42 hub leaf42 1k
R43 hub leaf43 1k
R44 hub leaf44 1k
R45 hub leaf45 1k
R46 hub leaf46 1k
R47 hub leaf47 1k
R48 hub leaf48 1k
R49 hub leaf49 1k
R50 hub leaf50 1k
R51 hub leaf51 1k
R52 hub leaf52 1k
R53 hub leaf53 1k
R54 hub leaf54 1k
R55 hub leaf55 1k
R56 hub leaf56 1k
R57 hub leaf57 1k
R58 hub leaf58 1k
R59 hub leaf59 1k
R60 hub leaf60 1k
R61 hub leaf61 1k
R62 hub leaf62 1k
R63 hub leaf63 1k
R64 hub leaf64 1k
R65 hub leaf65 1k
R66 hub leaf66 1k
R67 hub leaf67 1k
R68 hub leaf68 1k
R69 hub leaf69 1k
R70 hub leaf70 1k
R71 hub leaf71 1k
R72 hub leaf72 1k
R73 hub leaf73 1k
R74 hub leaf74 1k
R75 hub leaf75 1k
R76 hub leaf76 1k
R77 hub leaf77 1k
R78 hub leaf78 1k
R79 hub leaf79 1k
R80 hub leaf80 1k
R81 hub leaf81 1k
R82 hub leaf82 1k
R83 hub leaf83 1k
R84 hub leaf84 1k
R85 hub leaf85 1k
R86 hub leaf86 1k
R87 hub leaf87 1k
R88 hub leaf88 1k
R89 hub leaf89 1k
R90 hub leaf90 1k
R91 hub leaf91 1k
R92 hub leaf92 1k
R93 hub leaf93 1k
R94 hub leaf94 1k
R95 hub leaf95 1k
R96 hub leaf96 1k
R97 hub leaf97 1k
R98 hub leaf98 1k
R99 hub leaf99 1k
R100 hub leaf100 1k
R101 hub leaf101 1k
R102 hub leaf102 1k
R103 hub leaf103 1k
R104 hub leaf104 1k
R105 hub leaf105 1k
R106 hub leaf106 1k
R107 hub leaf107 1k
R108 hub leaf108 1k
R109 hub leaf109 1k
R110 hub leaf110 1k
R111 hub leaf111 1k
R112 hub leaf112 1k
R113 hub leaf113 1k
R114 hub leaf114 1k
R115 hub leaf115 1k
R116 hub leaf116 1k
R117 hub leaf117 1k
R118 hub leaf118 1k
R119 hub leaf119 1k
R120 hub leaf120 1k
R121 hub leaf121 1k
R122 hub leaf122 1k
R123 hub leaf123 1k
R124 hub leaf124 1k
R125 hub leaf125 1k
R126 hub leaf126 1k
R127 hub leaf127 1k
R128 hub leaf128 1k
R129 hub leaf129 1k
R130 hub leaf130 1k
R131 hub leaf131 1k
R132 hub leaf132 1k
R133 hub leaf133 1k
R134 hub leaf134 1k
R135 hub leaf135 1k
R136 hub leaf136 1k
R137 hub leaf137 1k
R138 hub leaf138 1k
R139 hub leaf139 1k
R140 hub leaf140 1k
R141 hub leaf141 1k
R142 hub leaf142 1k
R143 hub leaf143 1k
R144 hub leaf144 1k
R145 hub leaf145 1k
R146 hub leaf146 1k
R147 hub leaf147 1k
R148 hub leaf148 1k
R149 hub leaf149 1k
R150 hub leaf150 1k
R151 hub leaf151 1k
R152 hub leaf152 1k
R153 hub leaf153 1k
R154 hub leaf154 1k
R155 hub leaf155 1k
R156 hub leaf156 1k
R157 hub leaf157 1k
R158 hub leaf158 1k
R159 hub leaf159 1k
R160 hub leaf160 1k
R161 hub leaf161 1k
R162 hub leaf162 1k
R163 hub leaf163 1k
R164 hub leaf164 1k
R165 hub leaf165 1k
R166 hub leaf166 1k
R167 hub leaf167 1k
R168 hub leaf168 1k
R169 hub leaf169 1k
R170 hub leaf170 1k
R171 hub leaf171 1k
R172 hub leaf172 1k
R173 hub leaf173 1k
R174 hub leaf174 1k
R175 hub leaf175 1k
R176 hub leaf176 1k
R177 hub leaf177 1k
R178 hub leaf178 1k
R179 hub leaf179 1k
R180 hub leaf180 1k
R181 hub leaf181 1k
R182 hub leaf182 1k
R183 hub leaf183 1k
R184 hub leaf184 1k
R185 hub leaf185 1k
R186 hub leaf186 1k
R187 hub leaf187 1k
R188 hub leaf188 1k
R189 hub leaf189 1k
R190 hub leaf190 1k
R191 hub leaf191 1k
R192 hub leaf192 1k
R193 hub leaf193 1k
R194 hub leaf194 1k
R195 hub leaf195 1k
R196 hub leaf196 1k
R197 hub leaf197 1k
R198 hub leaf198 1k
R199 hub leaf199 1k
R200 hub leaf200 1k
R201 hub leaf201 1k
R202 hub leaf202 1k
R203 hub leaf203 1k
R204 hub leaf204 1k
R205 hub leaf205 1k
R206 hub leaf206 1k
R207 hub leaf207 1k
R208 hub leaf208 1k
R209 hub leaf209 1k
R210 hub leaf210 1k
R211 hub leaf211 1k
R212 hub leaf212 1k
R213 hub leaf213 1k
R214 hub leaf214 1k
R215 hub leaf215 1k
R216 hub leaf216 1k
R217 hub leaf217 1k
R218 hub leaf218 1k
R219 hub leaf219 1k
R220 hub leaf220 1k
R221 hub leaf221 1k
R222 hub leaf222 1k
R223 hub leaf223 1k
R224 hub leaf224 1k
R225 hub leaf225 1k
R226 hub leaf226 1k
R227 hub leaf227 1k
R228 hub leaf228 1k
R229 hub leaf229 1k
R230 hub leaf230 1k
R231 hub leaf231 1k
R232 hub leaf232 1k
R233 hub leaf233 1k
R234 hub leaf234 1k
R235 hub leaf235 1k
R236 hub leaf236 1k
R237 hub leaf237 1k
R238 hub leaf238 1k
R239 hub leaf239 1k
R240 hub leaf240 1k
R241 hub leaf241 1k
R242 hub leaf242 1k
R243 hub leaf243 1k
R244 hub leaf244 1k
R245 hub leaf245 1k
R246 hub leaf246 1k
R247 hub leaf247 1k
R248 hub leaf248 1k
R249 hub leaf249 1k
R250 hub leaf250 1k
R251 hub leaf251 1k
R252 hub leaf252 1k
R253 hub leaf253 1k
R254 hub leaf254 1k
R255 hub leaf255 1k
* @RNL {
*   {#R0 #R1 #R2 #R3 #R4 #R5 #R6 #R7 #R8 #R9 #R10 #R11 #R12 #R13 #R14 #R15 #R16 #R17 #R18 #R19 #R20 #R21 #R22 #R23 #R24 #R25 #R26 #R27 #R28 #R29 #R30 #R31 #R32 #R33 #R34 #R35 #R36 #R37 #R38 #R39 #R40 #R41 #R42 #R43 #R44 #R45 #R46 #R47 #R48 #R49 #R50 #R51 #R52 #R53 #R54 #R55 #R56 #R57 #R58 #R59 #R60 #R61 #R62 #R63 #R64 #R65 #R66 #R67 #R68 #R69 #R70 #R71 #R72 #R73 #R74 #R75 #R76 #R77 #R78 #R79 #R80 #R81 #R82 #R83 #R84 #R85 #R86 #R87 #R88 #R89 #R90 #R91 #R92 #R93 #R94 #R95 #R96 #R97 #R98 #R99 #R100 #R101 #R102 #R103 #R104 #R105 #R106 #R107 #R108 #R109 #R110 #R111 #R112 #R113 #R114 #R115 #R116 #R117 #R118 #R119 #R120 #R121 #R122 #R123 #R124 #R125 #R126 #R127 #R128 #R129 #R130 #R131 #R132 #R133 #R134 #R135 #R136 #R137 #R138 #R139 #R140 #R141 #R142 #R143 #R144 #R145 #R146 #R147 #R148 #R149 #R150 #R151 #R152 #R153 #R154 #R155 #R156 #R157 #R158 #R159 #R160 #R161 #R162 #R163 #R164 #R165 #R166 #R167 #R168 #R169 #R170 #R171 #R172 #R173 #R174 #R175 #R176 #R177 #R178 #R179 #R180 #R181 #R182 #R183 #R184 #R185 #R186 #R187 #R188 #R189 #R190 #R191 #R192 #R193 #R194 #R195 #R196 #R197 #R198 #R199 #R200 #R201 #R202 #R203 #R204 #R205 #R206 #R207 #R208 #R209 #R210 #R211 #R212 #R213 #R214 #R215 #R216 #R217 #R218 #R219 #R220 #R221 #R222 #R223 #R224 #R225 #R226 #R227 #R228 #R229 #R230 #R231 #R232 #R233 #R234 #R235 #R236 #R237 #R238 #R239 #R240 #R241 #R242 #R243 #R244 #R245 #R246 #R247 #R248 #R249 #R250 #R251 #R252 #R253 #R254 #R255} @ALIGN("y");
*   {#R0 #R1 #R2 #R3 #R4 #R5 #R6 #R7 #R8 #R9 #R10 #R11 #R12 #R13 #R14 #R15 #R16 #R17 #R18 #R19 #R20 #R21 #R22 #R23 #R24 #R25 #R26 #R27 #R28 #R29 #R30 #R31 #R32 #R33 #R34 #R35 #R36 #R37 #R38 #R39 #R40 #R41 #R42 #R43 #R44 #R45 #R46 #R47 #R48 #R49 #R50 #R51 #R52 #R53 #R54 #R55 #R56 #R57 #R58 #R59 #R60 #R61 #R62 #R63 #R64 #R65 #R66 #R67 #R68 #R69 #R70 #R71 #R72 #R73 #R74 #R75 #R76 #R77 #R78 #R79 #R80 #R81 #R82 #R83 #R84 #R85 #R86 #R87 #R88 #R89 #R90 #R91 #R92 #R93 #R94 #R95 #R96 #R97 #R98 #R99 #R100 #R101 #R102 #R103 #R104 #R105 #R106 #R107 #R108 #R109 #R110 #R111 #R112 #R113 #R114 #R115 #R116 #R117 #R118 #R119 #R120 #R121 #R122 #R123 #R124 #R125 #R126 #R127 #R128 #R129 #R130 #R131 #R132 #R133 #R134 #R135 #R136 #R137 #R138 #R139 #R140 #R141 #R142 #R143 #R144 #R145 #R146 #R147 #R148 #R149 #R150 #R151 #R152 #R153 #R154 #R155 #R156 #R157 #R158 #R159 #R160 #R161 #R162 #R163 #R164 #R165 #R166 #R167 #R168 #R169 #R170 #R171 #R172 #R173 #R174 #R175 #R176 #R177 #R178 #R179 #R180 #R181 #R182 #R183 #R184 #R185 #R186 #R187 #R188 #R189 #R190 #R191 #R192 #R193 #R194 #R195 #R196 #R197 #R198 #R199 #R200 #R201 #R202 #R203 #R204 #R205 #R206 #R207 #R208 #R209 #R210 #R211 #R212 #R213 #R214 #R215 #R216 #R217 #R218 #R219 #R220 #R221 #R222 #R223 #R224 #R225 #R226 #R227 #R228 #R229 #R230 #R231 #R232 #R233 #R234 #R235 #R236 #R237 #R238 #R239 #R240 #R241 #R242 #R243 #R244 #R245 #R246 #R247 #R248 #R249 #R250 #R251 #R252 #R253 #R254 #R255} @ORDER("left-to-right");
*   $WIRE_NET_SET @ROUTE
* }
.end
