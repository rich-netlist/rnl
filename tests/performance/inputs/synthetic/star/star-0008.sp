* Synthetic star; n=8; generated by prepare_inputs.py
* @RNL(type="header") { @VERSION("0.3") }
R0 hub leaf0 1k
R1 hub leaf1 1k
R2 hub leaf2 1k
R3 hub leaf3 1k
R4 hub leaf4 1k
R5 hub leaf5 1k
R6 hub leaf6 1k
R7 hub leaf7 1k
* @RNL {
*   {#R0 #R1 #R2 #R3 #R4 #R5 #R6 #R7} @ALIGN("y");
*   {#R0 #R1 #R2 #R3 #R4 #R5 #R6 #R7} @ORDER("left-to-right");
*   $WIRE_NET_SET @ROUTE
* }
.end
