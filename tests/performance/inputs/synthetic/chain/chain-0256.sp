* Synthetic chain; n=256; generated by prepare_inputs.py
* @RNL(type="header") { @VERSION("0.3") }
R0 q0 q1 1k
R1 q1 q2 1k
R2 q2 q3 1k
R3 q3 q4 1k
R4 q4 q5 1k
R5 q5 q6 1k
R6 q6 q7 1k
R7 q7 q8 1k
R8 q8 q9 1k
R9 q9 q10 1k
R10 q10 q11 1k
R11 q11 q12 1k
R12 q12 q13 1k
R13 q13 q14 1k
R14 q14 q15 1k
R15 q15 q16 1k
R16 q16 q17 1k
R17 q17 q18 1k
R18 q18 q19 1k
R19 q19 q20 1k
R20 q20 q21 1k
R21 q21 q22 1k
R22 q22 q23 1k
R23 q23 q24 1k
R24 q24 q25 1k
R25 q25 q26 1k
R26 q26 q27 1k
R27 q27 q28 1k
R28 q28 q29 1k
R29 q29 q30 1k
R30 q30 q31 1k
R31 q31 q32 1k
R32 q32 q33 1k
R33 q33 q34 1k
R34 q34 q35 1k
R35 q35 q36 1k
R36 q36 q37 1k
R37 q37 q38 1k
R38 q38 q39 1k
R39 q39 q40 1k
R40 q40 q41 1k
R41 q41 q42 1k
R42 q42 q43 1k
R43 q43 q44 1k
R44 q44 q45 1k
R45 q45 q46 1k
R46 q46 q47 1k
R47 q47 q48 1k
R48 q48 q49 1k
R49 q49 q50 1k
R50 q50 q51 1k
R51 q51 q52 1k
R52 q52 q53 1k
R53 q53 q54 1k
R54 q54 q55 1k
R55 q55 q56 1k
R56 q56 q57 1k
R57 q57 q58 1k
R58 q58 q59 1k
R59 q59 q60 1k
R60 q60 q61 1k
R61 q61 q62 1k
R62 q62 q63 1k
R63 q63 q64 1k
R64 q64 q65 1k
R65 q65 q66 1k
R66 q66 q67 1k
R67 q67 q68 1k
R68 q68 q69 1k
R69 q69 q70 1k
R70 q70 q71 1k
R71 q71 q72 1k
R72 q72 q73 1k
R73 q73 q74 1k
R74 q74 q75 1k
R75 q75 q76 1k
R76 q76 q77 1k
R77 q77 q78 1k
R78 q78 q79 1k
R79 q79 q80 1k
R80 q80 q81 1k
R81 q81 q82 1k
R82 q82 q83 1k
R83 q83 q84 1k
R84 q84 q85 1k
R85 q85 q86 1k
R86 q86 q87 1k
R87 q87 q88 1k
R88 q88 q89 1k
R89 q89 q90 1k
R90 q90 q91 1k
R91 q91 q92 1k
R92 q92 q93 1k
R93 q93 q94 1k
R94 q94 q95 1k
R95 q95 q96 1k
R96 q96 q97 1k
R97 q97 q98 1k
R98 q98 q99 1k
R99 q99 q100 1k
R100 q100 q101 1k
R101 q101 q102 1k
R102 q102 q103 1k
R103 q103 q104 1k
R104 q104 q105 1k
R105 q105 q106 1k
R106 q106 q107 1k
R107 q107 q108 1k
R108 q108 q109 1k
R109 q109 q110 1k
R110 q110 q111 1k
R111 q111 q112 1k
R112 q112 q113 1k
R113 q113 q114 1k
R114 q114 q115 1k
R115 q115 q116 1k
R116 q116 q117 1k
R117 q117 q118 1k
R118 q118 q119 1k
R119 q119 q120 1k
R120 q120 q121 1k
R121 q121 q122 1k
R122 q122 q123 1k
R123 q123 q124 1k
R124 q124 q125 1k
R125 q125 q126 1k
R126 q126 q127 1k
R127 q127 q128 1k
R128 q128 q129 1k
R129 q129 q130 1k
R130 q130 q131 1k
R131 q131 q132 1k
R132 q132 q133 1k
R133 q133 q134 1k
R134 q134 q135 1k
R135 q135 q136 1k
R136 q136 q137 1k
R137 q137 q138 1k
R138 q138 q139 1k
R139 q139 q140 1k
R140 q140 q141 1k
R141 q141 q142 1k
R142 q142 q143 1k
R143 q143 q144 1k
R144 q144 q145 1k
R145 q145 q146 1k
R146 q146 q147 1k
R147 q147 q148 1k
R148 q148 q149 1k
R149 q149 q150 1k
R150 q150 q151 1k
R151 q151 q152 1k
R152 q152 q153 1k
R153 q153 q154 1k
R154 q154 q155 1k
R155 q155 q156 1k
R156 q156 q157 1k
R157 q157 q158 1k
R158 q158 q159 1k
R159 q159 q160 1k
R160 q160 q161 1k
R161 q161 q162 1k
R162 q162 q163 1k
R163 q163 q164 1k
R164 q164 q165 1k
R165 q165 q166 1k
R166 q166 q167 1k
R167 q167 q168 1k
R168 q168 q169 1k
R169 q169 q170 1k
R170 q170 q171 1k
R171 q171 q172 1k
R172 q172 q173 1k
R173 q173 q174 1k
R174 q174 q175 1k
R175 q175 q176 1k
R176 q176 q177 1k
R177 q177 q178 1k
R178 q178 q179 1k
R179 q179 q180 1k
R180 q180 q181 1k
R181 q181 q182 1k
R182 q182 q183 1k
R183 q183 q184 1k
R184 q184 q185 1k
R185 q185 q186 1k
R186 q186 q187 1k
R187 q187 q188 1k
R188 q188 q189 1k
R189 q189 q190 1k
R190 q190 q191 1k
R191 q191 q192 1k
R192 q192 q193 1k
R193 q193 q194 1k
R194 q194 q195 1k
R195 q195 q196 1k
R196 q196 q197 1k
R197 q197 q198 1k
R198 q198 q199 1k
R199 q199 q200 1k
R200 q200 q201 1k
R201 q201 q202 1k
R202 q202 q203 1k
R203 q203 q204 1k
R204 q204 q205 1k
R205 q205 q206 1k
R206 q206 q207 1k
R207 q207 q208 1k
R208 q208 q209 1k
R209 q209 q210 1k
R210 q210 q211 1k
R211 q211 q212 1k
R212 q212 q213 1k
R213 q213 q214 1k
R214 q214 q215 1k
R215 q215 q216 1k
R216 q216 q217 1k
R217 q217 q218 1k
R218 q218 q219 1k
R219 q219 q220 1k
R220 q220 q221 1k
R221 q221 q222 1k
R222 q222 q223 1k
R223 q223 q224 1k
R224 q224 q225 1k
R225 q225 q226 1k
R226 q226 q227 1k
R227 q227 q228 1k
R228 q228 q229 1k
R229 q229 q230 1k
R230 q230 q231 1k
R231 q231 q232 1k
R232 q232 q233 1k
R233 q233 q234 1k
R234 q234 q235 1k
R235 q235 q236 1k
R236 q236 q237 1k
R237 q237 q238 1k
R238 q238 q239 1k
R239 q239 q240 1k
R240 q240 q241 1k
R241 q241 q242 1k
R242 q242 q243 1k
R243 q243 q244 1k
R244 q244 q245 1k
R245 q245 q246 1k
R246 q246 q247 1k
R247 q247 q248 1k
R248 q248 q249 1k
R249 q249 q250 1k
R250 q250 q251 1k
R251 q251 q252 1k
R252 q252 q253 1k
R253 q253 q254 1k
R254 q254 q255 1k
R255 q255 q256 1k
* @RNL {
*   {#R0 #R1 #R2 #R3 #R4 #R5 #R6 #R7 #R8 #R9 #R10 #R11 #R12 #R13 #R14 #R15 #R16 #R17 #R18 #R19 #R20 #R21 #R22 #R23 #R24 #R25 #R26 #R27 #R28 #R29 #R30 #R31 #R32 #R33 #R34 #R35 #R36 #R37 #R38 #R39 #R40 #R41 #R42 #R43 #R44 #R45 #R46 #R47 #R48 #R49 #R50 #R51 #R52 #R53 #R54 #R55 #R56 #R57 #R58 #R59 #R60 #R61 #R62 #R63 #R64 #R65 #R66 #R67 #R68 #R69 #R70 #R71 #R72 #R73 #R74 #R75 #R76 #R77 #R78 #R79 #R80 #R81 #R82 #R83 #R84 #R85 #R86 #R87 #R88 #R89 #R90 #R91 #R92 #R93 #R94 #R95 #R96 #R97 #R98 #R99 #R100 #R101 #R102 #R103 #R104 #R105 #R106 #R107 #R108 #R109 #R110 #R111 #R112 #R113 #R114 #R115 #R116 #R117 #R118 #R119 #R120 #R121 #R122 #R123 #R124 #R125 #R126 #R127 #R128 #R129 #R130 #R131 #R132 #R133 #R134 #R135 #R136 #R137 #R138 #R139 #R140 #R141 #R142 #R143 #R144 #R145 #R146 #R147 #R148 #R149 #R150 #R151 #R152 #R153 #R154 #R155 #R156 #R157 #R158 #R159 #R160 #R161 #R162 #R163 #R164 #R165 #R166 #R167 #R168 #R169 #R170 #R171 #R172 #R173 #R174 #R175 #R176 #R177 #R178 #R179 #R180 #R181 #R182 #R183 #R184 #R185 #R186 #R187 #R188 #R189 #R190 #R191 #R192 #R193 #R194 #R195 #R196 #R197 #R198 #R199 #R200 #R201 #R202 #R203 #R204 #R205 #R206 #R207 #R208 #R209 #R210 #R211 #R212 #R213 #R214 #R215 #R216 #R217 #R218 #R219 #R220 #R221 #R222 #R223 #R224 #R225 #R226 #R227 #R228 #R229 #R230 #R231 #R232 #R233 #R234 #R235 #R236 #R237 #R238 #R239 #R240 #R241 #R242 #R243 #R244 #R245 #R246 #R247 #R248 #R249 #R250 #R251 #R252 #R253 #R254 #R255} @AS $FLOW;
*   $WIRE_NET_SET @ROUTE
* }
.end
