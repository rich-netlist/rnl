* Synthetic chain; n=512; generated by prepare_inputs.py
* @RNL(type="header") { @VERSION("0.3") }
R0 q0 q1 1k
R1 q1 q2 1k
R2 q2 q3 1k
R3 q3 q4 1k
R4 q4 q5 1k
R5 q5 q6 1k
R6 q6 q7 1k
R7 q7 q8 1k
R8 q8 q9 1k
R9 q9 q10 1k
R10 q10 q11 1k
R11 q11 q12 1k
R12 q12 q13 1k
R13 q13 q14 1k
R14 q14 q15 1k
R15 q15 q16 1k
R16 q16 q17 1k
R17 q17 q18 1k
R18 q18 q19 1k
R19 q19 q20 1k
R20 q20 q21 1k
R21 q21 q22 1k
R22 q22 q23 1k
R23 q23 q24 1k
R24 q24 q25 1k
R25 q25 q26 1k
R26 q26 q27 1k
R27 q27 q28 1k
R28 q28 q29 1k
R29 q29 q30 1k
R30 q30 q31 1k
R31 q31 q32 1k
R32 q32 q33 1k
R33 q33 q34 1k
R34 q34 q35 1k
R35 q35 q36 1k
R36 q36 q37 1k
R37 q37 q38 1k
R38 q38 q39 1k
R39 q39 q40 1k
R40 q40 q41 1k
R41 q41 q42 1k
R42 q42 q43 1k
R43 q43 q44 1k
R44 q44 q45 1k
R45 q45 q46 1k
R46 q46 q47 1k
R47 q47 q48 1k
R48 q48 q49 1k
R49 q49 q50 1k
R50 q50 q51 1k
R51 q51 q52 1k
R52 q52 q53 1k
R53 q53 q54 1k
R54 q54 q55 1k
R55 q55 q56 1k
R56 q56 q57 1k
R57 q57 q58 1k
R58 q58 q59 1k
R59 q59 q60 1k
R60 q60 q61 1k
R61 q61 q62 1k
R62 q62 q63 1k
R63 q63 q64 1k
R64 q64 q65 1k
R65 q65 q66 1k
R66 q66 q67 1k
R67 q67 q68 1k
R68 q68 q69 1k
R69 q69 q70 1k
R70 q70 q71 1k
R71 q71 q72 1k
R72 q72 q73 1k
R73 q73 q74 1k
R74 q74 q75 1k
R75 q75 q76 1k
R76 q76 q77 1k
R77 q77 q78 1k
R78 q78 q79 1k
R79 q79 q80 1k
R80 q80 q81 1k
R81 q81 q82 1k
R82 q82 q83 1k
R83 q83 q84 1k
R84 q84 q85 1k
R85 q85 q86 1k
R86 q86 q87 1k
R87 q87 q88 1k
R88 q88 q89 1k
R89 q89 q90 1k
R90 q90 q91 1k
R91 q91 q92 1k
R92 q92 q93 1k
R93 q93 q94 1k
R94 q94 q95 1k
R95 q95 q96 1k
R96 q96 q97 1k
R97 q97 q98 1k
R98 q98 q99 1k
R99 q99 q100 1k
R100 q100 q101 1k
R101 q101 q102 1k
R102 q102 q103 1k
R103 q103 q104 1k
R104 q104 q105 1k
R105 q105 q106 1k
R106 q106 q107 1k
R107 q107 q108 1k
R108 q108 q109 1k
R109 q109 q110 1k
R110 q110 q111 1k
R111 q111 q112 1k
R112 q112 q113 1k
R113 q113 q114 1k
R114 q114 q115 1k
R115 q115 q116 1k
R116 q116 q117 1k
R117 q117 q118 1k
R118 q118 q119 1k
R119 q119 q120 1k
R120 q120 q121 1k
R121 q121 q122 1k
R122 q122 q123 1k
R123 q123 q124 1k
R124 q124 q125 1k
R125 q125 q126 1k
R126 q126 q127 1k
R127 q127 q128 1k
R128 q128 q129 1k
R129 q129 q130 1k
R130 q130 q131 1k
R131 q131 q132 1k
R132 q132 q133 1k
R133 q133 q134 1k
R134 q134 q135 1k
R135 q135 q136 1k
R136 q136 q137 1k
R137 q137 q138 1k
R138 q138 q139 1k
R139 q139 q140 1k
R140 q140 q141 1k
R141 q141 q142 1k
R142 q142 q143 1k
R143 q143 q144 1k
R144 q144 q145 1k
R145 q145 q146 1k
R146 q146 q147 1k
R147 q147 q148 1k
R148 q148 q149 1k
R149 q149 q150 1k
R150 q150 q151 1k
R151 q151 q152 1k
R152 q152 q153 1k
R153 q153 q154 1k
R154 q154 q155 1k
R155 q155 q156 1k
R156 q156 q157 1k
R157 q157 q158 1k
R158 q158 q159 1k
R159 q159 q160 1k
R160 q160 q161 1k
R161 q161 q162 1k
R162 q162 q163 1k
R163 q163 q164 1k
R164 q164 q165 1k
R165 q165 q166 1k
R166 q166 q167 1k
R167 q167 q168 1k
R168 q168 q169 1k
R169 q169 q170 1k
R170 q170 q171 1k
R171 q171 q172 1k
R172 q172 q173 1k
R173 q173 q174 1k
R174 q174 q175 1k
R175 q175 q176 1k
R176 q176 q177 1k
R177 q177 q178 1k
R178 q178 q179 1k
R179 q179 q180 1k
R180 q180 q181 1k
R181 q181 q182 1k
R182 q182 q183 1k
R183 q183 q184 1k
R184 q184 q185 1k
R185 q185 q186 1k
R186 q186 q187 1k
R187 q187 q188 1k
R188 q188 q189 1k
R189 q189 q190 1k
R190 q190 q191 1k
R191 q191 q192 1k
R192 q192 q193 1k
R193 q193 q194 1k
R194 q194 q195 1k
R195 q195 q196 1k
R196 q196 q197 1k
R197 q197 q198 1k
R198 q198 q199 1k
R199 q199 q200 1k
R200 q200 q201 1k
R201 q201 q202 1k
R202 q202 q203 1k
R203 q203 q204 1k
R204 q204 q205 1k
R205 q205 q206 1k
R206 q206 q207 1k
R207 q207 q208 1k
R208 q208 q209 1k
R209 q209 q210 1k
R210 q210 q211 1k
R211 q211 q212 1k
R212 q212 q213 1k
R213 q213 q214 1k
R214 q214 q215 1k
R215 q215 q216 1k
R216 q216 q217 1k
R217 q217 q218 1k
R218 q218 q219 1k
R219 q219 q220 1k
R220 q220 q221 1k
R221 q221 q222 1k
R222 q222 q223 1k
R223 q223 q224 1k
R224 q224 q225 1k
R225 q225 q226 1k
R226 q226 q227 1k
R227 q227 q228 1k
R228 q228 q229 1k
R229 q229 q230 1k
R230 q230 q231 1k
R231 q231 q232 1k
R232 q232 q233 1k
R233 q233 q234 1k
R234 q234 q235 1k
R235 q235 q236 1k
R236 q236 q237 1k
R237 q237 q238 1k
R238 q238 q239 1k
R239 q239 q240 1k
R240 q240 q241 1k
R241 q241 q242 1k
R242 q242 q243 1k
R243 q243 q244 1k
R244 q244 q245 1k
R245 q245 q246 1k
R246 q246 q247 1k
R247 q247 q248 1k
R248 q248 q249 1k
R249 q249 q250 1k
R250 q250 q251 1k
R251 q251 q252 1k
R252 q252 q253 1k
R253 q253 q254 1k
R254 q254 q255 1k
R255 q255 q256 1k
R256 q256 q257 1k
R257 q257 q258 1k
R258 q258 q259 1k
R259 q259 q260 1k
R260 q260 q261 1k
R261 q261 q262 1k
R262 q262 q263 1k
R263 q263 q264 1k
R264 q264 q265 1k
R265 q265 q266 1k
R266 q266 q267 1k
R267 q267 q268 1k
R268 q268 q269 1k
R269 q269 q270 1k
R270 q270 q271 1k
R271 q271 q272 1k
R272 q272 q273 1k
R273 q273 q274 1k
R274 q274 q275 1k
R275 q275 q276 1k
R276 q276 q277 1k
R277 q277 q278 1k
R278 q278 q279 1k
R279 q279 q280 1k
R280 q280 q281 1k
R281 q281 q282 1k
R282 q282 q283 1k
R283 q283 q284 1k
R284 q284 q285 1k
R285 q285 q286 1k
R286 q286 q287 1k
R287 q287 q288 1k
R288 q288 q289 1k
R289 q289 q290 1k
R290 q290 q291 1k
R291 q291 q292 1k
R292 q292 q293 1k
R293 q293 q294 1k
R294 q294 q295 1k
R295 q295 q296 1k
R296 q296 q297 1k
R297 q297 q298 1k
R298 q298 q299 1k
R299 q299 q300 1k
R300 q300 q301 1k
R301 q301 q302 1k
R302 q302 q303 1k
R303 q303 q304 1k
R304 q304 q305 1k
R305 q305 q306 1k
R306 q306 q307 1k
R307 q307 q308 1k
R308 q308 q309 1k
R309 q309 q310 1k
R310 q310 q311 1k
R311 q311 q312 1k
R312 q312 q313 1k
R313 q313 q314 1k
R314 q314 q315 1k
R315 q315 q316 1k
R316 q316 q317 1k
R317 q317 q318 1k
R318 q318 q319 1k
R319 q319 q320 1k
R320 q320 q321 1k
R321 q321 q322 1k
R322 q322 q323 1k
R323 q323 q324 1k
R324 q324 q325 1k
R325 q325 q326 1k
R326 q326 q327 1k
R327 q327 q328 1k
R328 q328 q329 1k
R329 q329 q330 1k
R330 q330 q331 1k
R331 q331 q332 1k
R332 q332 q333 1k
R333 q333 q334 1k
R334 q334 q335 1k
R335 q335 q336 1k
R336 q336 q337 1k
R337 q337 q338 1k
R338 q338 q339 1k
R339 q339 q340 1k
R340 q340 q341 1k
R341 q341 q342 1k
R342 q342 q343 1k
R343 q343 q344 1k
R344 q344 q345 1k
R345 q345 q346 1k
R346 q346 q347 1k
R347 q347 q348 1k
R348 q348 q349 1k
R349 q349 q350 1k
R350 q350 q351 1k
R351 q351 q352 1k
R352 q352 q353 1k
R353 q353 q354 1k
R354 q354 q355 1k
R355 q355 q356 1k
R356 q356 q357 1k
R357 q357 q358 1k
R358 q358 q359 1k
R359 q359 q360 1k
R360 q360 q361 1k
R361 q361 q362 1k
R362 q362 q363 1k
R363 q363 q364 1k
R364 q364 q365 1k
R365 q365 q366 1k
R366 q366 q367 1k
R367 q367 q368 1k
R368 q368 q369 1k
R369 q369 q370 1k
R370 q370 q371 1k
R371 q371 q372 1k
R372 q372 q373 1k
R373 q373 q374 1k
R374 q374 q375 1k
R375 q375 q376 1k
R376 q376 q377 1k
R377 q377 q378 1k
R378 q378 q379 1k
R379 q379 q380 1k
R380 q380 q381 1k
R381 q381 q382 1k
R382 q382 q383 1k
R383 q383 q384 1k
R384 q384 q385 1k
R385 q385 q386 1k
R386 q386 q387 1k
R387 q387 q388 1k
R388 q388 q389 1k
R389 q389 q390 1k
R390 q390 q391 1k
R391 q391 q392 1k
R392 q392 q393 1k
R393 q393 q394 1k
R394 q394 q395 1k
R395 q395 q396 1k
R396 q396 q397 1k
R397 q397 q398 1k
R398 q398 q399 1k
R399 q399 q400 1k
R400 q400 q401 1k
R401 q401 q402 1k
R402 q402 q403 1k
R403 q403 q404 1k
R404 q404 q405 1k
R405 q405 q406 1k
R406 q406 q407 1k
R407 q407 q408 1k
R408 q408 q409 1k
R409 q409 q410 1k
R410 q410 q411 1k
R411 q411 q412 1k
R412 q412 q413 1k
R413 q413 q414 1k
R414 q414 q415 1k
R415 q415 q416 1k
R416 q416 q417 1k
R417 q417 q418 1k
R418 q418 q419 1k
R419 q419 q420 1k
R420 q420 q421 1k
R421 q421 q422 1k
R422 q422 q423 1k
R423 q423 q424 1k
R424 q424 q425 1k
R425 q425 q426 1k
R426 q426 q427 1k
R427 q427 q428 1k
R428 q428 q429 1k
R429 q429 q430 1k
R430 q430 q431 1k
R431 q431 q432 1k
R432 q432 q433 1k
R433 q433 q434 1k
R434 q434 q435 1k
R435 q435 q436 1k
R436 q436 q437 1k
R437 q437 q438 1k
R438 q438 q439 1k
R439 q439 q440 1k
R440 q440 q441 1k
R441 q441 q442 1k
R442 q442 q443 1k
R443 q443 q444 1k
R444 q444 q445 1k
R445 q445 q446 1k
R446 q446 q447 1k
R447 q447 q448 1k
R448 q448 q449 1k
R449 q449 q450 1k
R450 q450 q451 1k
R451 q451 q452 1k
R452 q452 q453 1k
R453 q453 q454 1k
R454 q454 q455 1k
R455 q455 q456 1k
R456 q456 q457 1k
R457 q457 q458 1k
R458 q458 q459 1k
R459 q459 q460 1k
R460 q460 q461 1k
R461 q461 q462 1k
R462 q462 q463 1k
R463 q463 q464 1k
R464 q464 q465 1k
R465 q465 q466 1k
R466 q466 q467 1k
R467 q467 q468 1k
R468 q468 q469 1k
R469 q469 q470 1k
R470 q470 q471 1k
R471 q471 q472 1k
R472 q472 q473 1k
R473 q473 q474 1k
R474 q474 q475 1k
R475 q475 q476 1k
R476 q476 q477 1k
R477 q477 q478 1k
R478 q478 q479 1k
R479 q479 q480 1k
R480 q480 q481 1k
R481 q481 q482 1k
R482 q482 q483 1k
R483 q483 q484 1k
R484 q484 q485 1k
R485 q485 q486 1k
R486 q486 q487 1k
R487 q487 q488 1k
R488 q488 q489 1k
R489 q489 q490 1k
R490 q490 q491 1k
R491 q491 q492 1k
R492 q492 q493 1k
R493 q493 q494 1k
R494 q494 q495 1k
R495 q495 q496 1k
R496 q496 q497 1k
R497 q497 q498 1k
R498 q498 q499 1k
R499 q499 q500 1k
R500 q500 q501 1k
R501 q501 q502 1k
R502 q502 q503 1k
R503 q503 q504 1k
R504 q504 q505 1k
R505 q505 q506 1k
R506 q506 q507 1k
R507 q507 q508 1k
R508 q508 q509 1k
R509 q509 q510 1k
R510 q510 q511 1k
R511 q511 q512 1k
* @RNL {
*   {#R0 #R1 #R2 #R3 #R4 #R5 #R6 #R7 #R8 #R9 #R10 #R11 #R12 #R13 #R14 #R15 #R16 #R17 #R18 #R19 #R20 #R21 #R22 #R23 #R24 #R25 #R26 #R27 #R28 #R29 #R30 #R31 #R32 #R33 #R34 #R35 #R36 #R37 #R38 #R39 #R40 #R41 #R42 #R43 #R44 #R45 #R46 #R47 #R48 #R49 #R50 #R51 #R52 #R53 #R54 #R55 #R56 #R57 #R58 #R59 #R60 #R61 #R62 #R63 #R64 #R65 #R66 #R67 #R68 #R69 #R70 #R71 #R72 #R73 #R74 #R75 #R76 #R77 #R78 #R79 #R80 #R81 #R82 #R83 #R84 #R85 #R86 #R87 #R88 #R89 #R90 #R91 #R92 #R93 #R94 #R95 #R96 #R97 #R98 #R99 #R100 #R101 #R102 #R103 #R104 #R105 #R106 #R107 #R108 #R109 #R110 #R111 #R112 #R113 #R114 #R115 #R116 #R117 #R118 #R119 #R120 #R121 #R122 #R123 #R124 #R125 #R126 #R127 #R128 #R129 #R130 #R131 #R132 #R133 #R134 #R135 #R136 #R137 #R138 #R139 #R140 #R141 #R142 #R143 #R144 #R145 #R146 #R147 #R148 #R149 #R150 #R151 #R152 #R153 #R154 #R155 #R156 #R157 #R158 #R159 #R160 #R161 #R162 #R163 #R164 #R165 #R166 #R167 #R168 #R169 #R170 #R171 #R172 #R173 #R174 #R175 #R176 #R177 #R178 #R179 #R180 #R181 #R182 #R183 #R184 #R185 #R186 #R187 #R188 #R189 #R190 #R191 #R192 #R193 #R194 #R195 #R196 #R197 #R198 #R199 #R200 #R201 #R202 #R203 #R204 #R205 #R206 #R207 #R208 #R209 #R210 #R211 #R212 #R213 #R214 #R215 #R216 #R217 #R218 #R219 #R220 #R221 #R222 #R223 #R224 #R225 #R226 #R227 #R228 #R229 #R230 #R231 #R232 #R233 #R234 #R235 #R236 #R237 #R238 #R239 #R240 #R241 #R242 #R243 #R244 #R245 #R246 #R247 #R248 #R249 #R250 #R251 #R252 #R253 #R254 #R255 #R256 #R257 #R258 #R259 #R260 #R261 #R262 #R263 #R264 #R265 #R266 #R267 #R268 #R269 #R270 #R271 #R272 #R273 #R274 #R275 #R276 #R277 #R278 #R279 #R280 #R281 #R282 #R283 #R284 #R285 #R286 #R287 #R288 #R289 #R290 #R291 #R292 #R293 #R294 #R295 #R296 #R297 #R298 #R299 #R300 #R301 #R302 #R303 #R304 #R305 #R306 #R307 #R308 #R309 #R310 #R311 #R312 #R313 #R314 #R315 #R316 #R317 #R318 #R319 #R320 #R321 #R322 #R323 #R324 #R325 #R326 #R327 #R328 #R329 #R330 #R331 #R332 #R333 #R334 #R335 #R336 #R337 #R338 #R339 #R340 #R341 #R342 #R343 #R344 #R345 #R346 #R347 #R348 #R349 #R350 #R351 #R352 #R353 #R354 #R355 #R356 #R357 #R358 #R359 #R360 #R361 #R362 #R363 #R364 #R365 #R366 #R367 #R368 #R369 #R370 #R371 #R372 #R373 #R374 #R375 #R376 #R377 #R378 #R379 #R380 #R381 #R382 #R383 #R384 #R385 #R386 #R387 #R388 #R389 #R390 #R391 #R392 #R393 #R394 #R395 #R396 #R397 #R398 #R399 #R400 #R401 #R402 #R403 #R404 #R405 #R406 #R407 #R408 #R409 #R410 #R411 #R412 #R413 #R414 #R415 #R416 #R417 #R418 #R419 #R420 #R421 #R422 #R423 #R424 #R425 #R426 #R427 #R428 #R429 #R430 #R431 #R432 #R433 #R434 #R435 #R436 #R437 #R438 #R439 #R440 #R441 #R442 #R443 #R444 #R445 #R446 #R447 #R448 #R449 #R450 #R451 #R452 #R453 #R454 #R455 #R456 #R457 #R458 #R459 #R460 #R461 #R462 #R463 #R464 #R465 #R466 #R467 #R468 #R469 #R470 #R471 #R472 #R473 #R474 #R475 #R476 #R477 #R478 #R479 #R480 #R481 #R482 #R483 #R484 #R485 #R486 #R487 #R488 #R489 #R490 #R491 #R492 #R493 #R494 #R495 #R496 #R497 #R498 #R499 #R500 #R501 #R502 #R503 #R504 #R505 #R506 #R507 #R508 #R509 #R510 #R511} @AS $FLOW;
*   $WIRE_NET_SET @ROUTE
* }
.end
