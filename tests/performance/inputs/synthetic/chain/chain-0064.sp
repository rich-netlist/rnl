* Synthetic chain; n=64; generated by prepare_inputs.py
* @RNL(type="header") { @VERSION("0.3") }
R0 q0 q1 1k
R1 q1 q2 1k
R2 q2 q3 1k
R3 q3 q4 1k
R4 q4 q5 1k
R5 q5 q6 1k
R6 q6 q7 1k
R7 q7 q8 1k
R8 q8 q9 1k
R9 q9 q10 1k
R10 q10 q11 1k
R11 q11 q12 1k
R12 q12 q13 1k
R13 q13 q14 1k
R14 q14 q15 1k
R15 q15 q16 1k
R16 q16 q17 1k
R17 q17 q18 1k
R18 q18 q19 1k
R19 q19 q20 1k
R20 q20 q21 1k
R21 q21 q22 1k
R22 q22 q23 1k
R23 q23 q24 1k
R24 q24 q25 1k
R25 q25 q26 1k
R26 q26 q27 1k
R27 q27 q28 1k
R28 q28 q29 1k
R29 q29 q30 1k
R30 q30 q31 1k
R31 q31 q32 1k
R32 q32 q33 1k
R33 q33 q34 1k
R34 q34 q35 1k
R35 q35 q36 1k
R36 q36 q37 1k
R37 q37 q38 1k
R38 q38 q39 1k
R39 q39 q40 1k
R40 q40 q41 1k
R41 q41 q42 1k
R42 q42 q43 1k
R43 q43 q44 1k
R44 q44 q45 1k
R45 q45 q46 1k
R46 q46 q47 1k
R47 q47 q48 1k
R48 q48 q49 1k
R49 q49 q50 1k
R50 q50 q51 1k
R51 q51 q52 1k
R52 q52 q53 1k
R53 q53 q54 1k
R54 q54 q55 1k
R55 q55 q56 1k
R56 q56 q57 1k
R57 q57 q58 1k
R58 q58 q59 1k
R59 q59 q60 1k
R60 q60 q61 1k
R61 q61 q62 1k
R62 q62 q63 1k
R63 q63 q64 1k
* @RNL {
*   {#R0 #R1 #R2 #R3 #R4 #R5 #R6 #R7 #R8 #R9 #R10 #R11 #R12 #R13 #R14 #R15 #R16 #R17 #R18 #R19 #R20 #R21 #R22 #R23 #R24 #R25 #R26 #R27 #R28 #R29 #R30 #R31 #R32 #R33 #R34 #R35 #R36 #R37 #R38 #R39 #R40 #R41 #R42 #R43 #R44 #R45 #R46 #R47 #R48 #R49 #R50 #R51 #R52 #R53 #R54 #R55 #R56 #R57 #R58 #R59 #R60 #R61 #R62 #R63} @AS $FLOW;
*   $WIRE_NET_SET @ROUTE
* }
.end
