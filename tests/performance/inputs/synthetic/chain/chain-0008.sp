* Synthetic chain; n=8; generated by prepare_inputs.py
* @RNL(type="header") { @VERSION("0.3") }
R0 q0 q1 1k
R1 q1 q2 1k
R2 q2 q3 1k
R3 q3 q4 1k
R4 q4 q5 1k
R5 q5 q6 1k
R6 q6 q7 1k
R7 q7 q8 1k
* @RNL {
*   {#R0 #R1 #R2 #R3 #R4 #R5 #R6 #R7} @AS $FLOW;
*   $WIRE_NET_SET @ROUTE
* }
.end
