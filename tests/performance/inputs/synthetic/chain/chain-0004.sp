* Synthetic chain; n=4; generated by prepare_inputs.py
* @RNL(type="header") { @VERSION("0.3") }
R0 q0 q1 1k
R1 q1 q2 1k
R2 q2 q3 1k
R3 q3 q4 1k
* @RNL {
*   {#R0 #R1 #R2 #R3} @AS $FLOW;
*   $WIRE_NET_SET @ROUTE
* }
.end
