* Synthetic chain; n=2; generated by prepare_inputs.py
* @RNL(type="header") { @VERSION("0.3") }
R0 q0 q1 1k
R1 q1 q2 1k
* @RNL {
*   {#R0 #R1} @AS $FLOW;
*   $WIRE_NET_SET @ROUTE
* }
.end
