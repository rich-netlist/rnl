* Synthetic chain; n=128; generated by prepare_inputs.py
* @RNL(type="header") { @VERSION("0.3") }
R0 q0 q1 1k
R1 q1 q2 1k
R2 q2 q3 1k
R3 q3 q4 1k
R4 q4 q5 1k
R5 q5 q6 1k
R6 q6 q7 1k
R7 q7 q8 1k
R8 q8 q9 1k
R9 q9 q10 1k
R10 q10 q11 1k
R11 q11 q12 1k
R12 q12 q13 1k
R13 q13 q14 1k
R14 q14 q15 1k
R15 q15 q16 1k
R16 q16 q17 1k
R17 q17 q18 1k
R18 q18 q19 1k
R19 q19 q20 1k
R20 q20 q21 1k
R21 q21 q22 1k
R22 q22 q23 1k
R23 q23 q24 1k
R24 q24 q25 1k
R25 q25 q26 1k
R26 q26 q27 1k
R27 q27 q28 1k
R28 q28 q29 1k
R29 q29 q30 1k
R30 q30 q31 1k
R31 q31 q32 1k
R32 q32 q33 1k
R33 q33 q34 1k
R34 q34 q35 1k
R35 q35 q36 1k
R36 q36 q37 1k
R37 q37 q38 1k
R38 q38 q39 1k
R39 q39 q40 1k
R40 q40 q41 1k
R41 q41 q42 1k
R42 q42 q43 1k
R43 q43 q44 1k
R44 q44 q45 1k
R45 q45 q46 1k
R46 q46 q47 1k
R47 q47 q48 1k
R48 q48 q49 1k
R49 q49 q50 1k
R50 q50 q51 1k
R51 q51 q52 1k
R52 q52 q53 1k
R53 q53 q54 1k
R54 q54 q55 1k
R55 q55 q56 1k
R56 q56 q57 1k
R57 q57 q58 1k
R58 q58 q59 1k
R59 q59 q60 1k
R60 q60 q61 1k
R61 q61 q62 1k
R62 q62 q63 1k
R63 q63 q64 1k
R64 q64 q65 1k
R65 q65 q66 1k
R66 q66 q67 1k
R67 q67 q68 1k
R68 q68 q69 1k
R69 q69 q70 1k
R70 q70 q71 1k
R71 q71 q72 1k
R72 q72 q73 1k
R73 q73 q74 1k
R74 q74 q75 1k
R75 q75 q76 1k
R76 q76 q77 1k
R77 q77 q78 1k
R78 q78 q79 1k
R79 q79 q80 1k
R80 q80 q81 1k
R81 q81 q82 1k
R82 q82 q83 1k
R83 q83 q84 1k
R84 q84 q85 1k
R85 q85 q86 1k
R86 q86 q87 1k
R87 q87 q88 1k
R88 q88 q89 1k
R89 q89 q90 1k
R90 q90 q91 1k
R91 q91 q92 1k
R92 q92 q93 1k
R93 q93 q94 1k
R94 q94 q95 1k
R95 q95 q96 1k
R96 q96 q97 1k
R97 q97 q98 1k
R98 q98 q99 1k
R99 q99 q100 1k
R100 q100 q101 1k
R101 q101 q102 1k
R102 q102 q103 1k
R103 q103 q104 1k
R104 q104 q105 1k
R105 q105 q106 1k
R106 q106 q107 1k
R107 q107 q108 1k
R108 q108 q109 1k
R109 q109 q110 1k
R110 q110 q111 1k
R111 q111 q112 1k
R112 q112 q113 1k
R113 q113 q114 1k
R114 q114 q115 1k
R115 q115 q116 1k
R116 q116 q117 1k
R117 q117 q118 1k
R118 q118 q119 1k
R119 q119 q120 1k
R120 q120 q121 1k
R121 q121 q122 1k
R122 q122 q123 1k
R123 q123 q124 1k
R124 q124 q125 1k
R125 q125 q126 1k
R126 q126 q127 1k
R127 q127 q128 1k
* @RNL {
*   {#R0 #R1 #R2 #R3 #R4 #R5 #R6 #R7 #R8 #R9 #R10 #R11 #R12 #R13 #R14 #R15 #R16 #R17 #R18 #R19 #R20 #R21 #R22 #R23 #R24 #R25 #R26 #R27 #R28 #R29 #R30 #R31 #R32 #R33 #R34 #R35 #R36 #R37 #R38 #R39 #R40 #R41 #R42 #R43 #R44 #R45 #R46 #R47 #R48 #R49 #R50 #R51 #R52 #R53 #R54 #R55 #R56 #R57 #R58 #R59 #R60 #R61 #R62 #R63 #R64 #R65 #R66 #R67 #R68 #R69 #R70 #R71 #R72 #R73 #R74 #R75 #R76 #R77 #R78 #R79 #R80 #R81 #R82 #R83 #R84 #R85 #R86 #R87 #R88 #R89 #R90 #R91 #R92 #R93 #R94 #R95 #R96 #R97 #R98 #R99 #R100 #R101 #R102 #R103 #R104 #R105 #R106 #R107 #R108 #R109 #R110 #R111 #R112 #R113 #R114 #R115 #R116 #R117 #R118 #R119 #R120 #R121 #R122 #R123 #R124 #R125 #R126 #R127} @AS $FLOW;
*   $WIRE_NET_SET @ROUTE
* }
.end
