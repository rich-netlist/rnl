* Synthetic diffmirror; n=32; generated by prepare_inputs.py
* @RNL(type="header") { @VERSION("0.3") }
.model nch nmos level=1
.model pch pmos level=1
M0a x0 inp0 tail0 vss nch W=2u L=0.5u
M0b out0 inn0 tail0 vss nch W=2u L=0.5u
M0c x0 x0 vdd vdd pch W=4u L=0.5u
M0d out0 x0 vdd vdd pch W=4u L=0.5u
M0t tail0 vbias vss vss nch W=4u L=1u
M1a x1 inp1 tail1 vss nch W=2u L=0.5u
M1b out1 inn1 tail1 vss nch W=2u L=0.5u
M1c x1 x1 vdd vdd pch W=4u L=0.5u
M1d out1 x1 vdd vdd pch W=4u L=0.5u
M1t tail1 vbias vss vss nch W=4u L=1u
M2a x2 inp2 tail2 vss nch W=2u L=0.5u
M2b out2 inn2 tail2 vss nch W=2u L=0.5u
M2c x2 x2 vdd vdd pch W=4u L=0.5u
M2d out2 x2 vdd vdd pch W=4u L=0.5u
M2t tail2 vbias vss vss nch W=4u L=1u
M3a x3 inp3 tail3 vss nch W=2u L=0.5u
M3b out3 inn3 tail3 vss nch W=2u L=0.5u
M3c x3 x3 vdd vdd pch W=4u L=0.5u
M3d out3 x3 vdd vdd pch W=4u L=0.5u
M3t tail3 vbias vss vss nch W=4u L=1u
M4a x4 inp4 tail4 vss nch W=2u L=0.5u
M4b out4 inn4 tail4 vss nch W=2u L=0.5u
M4c x4 x4 vdd vdd pch W=4u L=0.5u
M4d out4 x4 vdd vdd pch W=4u L=0.5u
M4t tail4 vbias vss vss nch W=4u L=1u
M5a x5 inp5 tail5 vss nch W=2u L=0.5u
M5b out5 inn5 tail5 vss nch W=2u L=0.5u
M5c x5 x5 vdd vdd pch W=4u L=0.5u
M5d out5 x5 vdd vdd pch W=4u L=0.5u
M5t tail5 vbias vss vss nch W=4u L=1u
M6a x6 inp6 tail6 vss nch W=2u L=0.5u
M6b out6 inn6 tail6 vss nch W=2u L=0.5u
M6c x6 x6 vdd vdd pch W=4u L=0.5u
M6d out6 x6 vdd vdd pch W=4u L=0.5u
M6t tail6 vbias vss vss nch W=4u L=1u
M7a x7 inp7 tail7 vss nch W=2u L=0.5u
M7b out7 inn7 tail7 vss nch W=2u L=0.5u
M7c x7 x7 vdd vdd pch W=4u L=0.5u
M7d out7 x7 vdd vdd pch W=4u L=0.5u
M7t tail7 vbias vss vss nch W=4u L=1u
M8a x8 inp8 tail8 vss nch W=2u L=0.5u
M8b out8 inn8 tail8 vss nch W=2u L=0.5u
M8c x8 x8 vdd vdd pch W=4u L=0.5u
M8d out8 x8 vdd vdd pch W=4u L=0.5u
M8t tail8 vbias vss vss nch W=4u L=1u
M9a x9 inp9 tail9 vss nch W=2u L=0.5u
M9b out9 inn9 tail9 vss nch W=2u L=0.5u
M9c x9 x9 vdd vdd pch W=4u L=0.5u
M9d out9 x9 vdd vdd pch W=4u L=0.5u
M9t tail9 vbias vss vss nch W=4u L=1u
M10a x10 inp10 tail10 vss nch W=2u L=0.5u
M10b out10 inn10 tail10 vss nch W=2u L=0.5u
M10c x10 x10 vdd vdd pch W=4u L=0.5u
M10d out10 x10 vdd vdd pch W=4u L=0.5u
M10t tail10 vbias vss vss nch W=4u L=1u
M11a x11 inp11 tail11 vss nch W=2u L=0.5u
M11b out11 inn11 tail11 vss nch W=2u L=0.5u
M11c x11 x11 vdd vdd pch W=4u L=0.5u
M11d out11 x11 vdd vdd pch W=4u L=0.5u
M11t tail11 vbias vss vss nch W=4u L=1u
M12a x12 inp12 tail12 vss nch W=2u L=0.5u
M12b out12 inn12 tail12 vss nch W=2u L=0.5u
M12c x12 x12 vdd vdd pch W=4u L=0.5u
M12d out12 x12 vdd vdd pch W=4u L=0.5u
M12t tail12 vbias vss vss nch W=4u L=1u
M13a x13 inp13 tail13 vss nch W=2u L=0.5u
M13b out13 inn13 tail13 vss nch W=2u L=0.5u
M13c x13 x13 vdd vdd pch W=4u L=0.5u
M13d out13 x13 vdd vdd pch W=4u L=0.5u
M13t tail13 vbias vss vss nch W=4u L=1u
M14a x14 inp14 tail14 vss nch W=2u L=0.5u
M14b out14 inn14 tail14 vss nch W=2u L=0.5u
M14c x14 x14 vdd vdd pch W=4u L=0.5u
M14d out14 x14 vdd vdd pch W=4u L=0.5u
M14t tail14 vbias vss vss nch W=4u L=1u
M15a x15 inp15 tail15 vss nch W=2u L=0.5u
M15b out15 inn15 tail15 vss nch W=2u L=0.5u
M15c x15 x15 vdd vdd pch W=4u L=0.5u
M15d out15 x15 vdd vdd pch W=4u L=0.5u
M15t tail15 vbias vss vss nch W=4u L=1u
M16a x16 inp16 tail16 vss nch W=2u L=0.5u
M16b out16 inn16 tail16 vss nch W=2u L=0.5u
M16c x16 x16 vdd vdd pch W=4u L=0.5u
M16d out16 x16 vdd vdd pch W=4u L=0.5u
M16t tail16 vbias vss vss nch W=4u L=1u
M17a x17 inp17 tail17 vss nch W=2u L=0.5u
M17b out17 inn17 tail17 vss nch W=2u L=0.5u
M17c x17 x17 vdd vdd pch W=4u L=0.5u
M17d out17 x17 vdd vdd pch W=4u L=0.5u
M17t tail17 vbias vss vss nch W=4u L=1u
M18a x18 inp18 tail18 vss nch W=2u L=0.5u
M18b out18 inn18 tail18 vss nch W=2u L=0.5u
M18c x18 x18 vdd vdd pch W=4u L=0.5u
M18d out18 x18 vdd vdd pch W=4u L=0.5u
M18t tail18 vbias vss vss nch W=4u L=1u
M19a x19 inp19 tail19 vss nch W=2u L=0.5u
M19b out19 inn19 tail19 vss nch W=2u L=0.5u
M19c x19 x19 vdd vdd pch W=4u L=0.5u
M19d out19 x19 vdd vdd pch W=4u L=0.5u
M19t tail19 vbias vss vss nch W=4u L=1u
M20a x20 inp20 tail20 vss nch W=2u L=0.5u
M20b out20 inn20 tail20 vss nch W=2u L=0.5u
M20c x20 x20 vdd vdd pch W=4u L=0.5u
M20d out20 x20 vdd vdd pch W=4u L=0.5u
M20t tail20 vbias vss vss nch W=4u L=1u
M21a x21 inp21 tail21 vss nch W=2u L=0.5u
M21b out21 inn21 tail21 vss nch W=2u L=0.5u
M21c x21 x21 vdd vdd pch W=4u L=0.5u
M21d out21 x21 vdd vdd pch W=4u L=0.5u
M21t tail21 vbias vss vss nch W=4u L=1u
M22a x22 inp22 tail22 vss nch W=2u L=0.5u
M22b out22 inn22 tail22 vss nch W=2u L=0.5u
M22c x22 x22 vdd vdd pch W=4u L=0.5u
M22d out22 x22 vdd vdd pch W=4u L=0.5u
M22t tail22 vbias vss vss nch W=4u L=1u
M23a x23 inp23 tail23 vss nch W=2u L=0.5u
M23b out23 inn23 tail23 vss nch W=2u L=0.5u
M23c x23 x23 vdd vdd pch W=4u L=0.5u
M23d out23 x23 vdd vdd pch W=4u L=0.5u
M23t tail23 vbias vss vss nch W=4u L=1u
M24a x24 inp24 tail24 vss nch W=2u L=0.5u
M24b out24 inn24 tail24 vss nch W=2u L=0.5u
M24c x24 x24 vdd vdd pch W=4u L=0.5u
M24d out24 x24 vdd vdd pch W=4u L=0.5u
M24t tail24 vbias vss vss nch W=4u L=1u
M25a x25 inp25 tail25 vss nch W=2u L=0.5u
M25b out25 inn25 tail25 vss nch W=2u L=0.5u
M25c x25 x25 vdd vdd pch W=4u L=0.5u
M25d out25 x25 vdd vdd pch W=4u L=0.5u
M25t tail25 vbias vss vss nch W=4u L=1u
M26a x26 inp26 tail26 vss nch W=2u L=0.5u
M26b out26 inn26 tail26 vss nch W=2u L=0.5u
M26c x26 x26 vdd vdd pch W=4u L=0.5u
M26d out26 x26 vdd vdd pch W=4u L=0.5u
M26t tail26 vbias vss vss nch W=4u L=1u
M27a x27 inp27 tail27 vss nch W=2u L=0.5u
M27b out27 inn27 tail27 vss nch W=2u L=0.5u
M27c x27 x27 vdd vdd pch W=4u L=0.5u
M27d out27 x27 vdd vdd pch W=4u L=0.5u
M27t tail27 vbias vss vss nch W=4u L=1u
M28a x28 inp28 tail28 vss nch W=2u L=0.5u
M28b out28 inn28 tail28 vss nch W=2u L=0.5u
M28c x28 x28 vdd vdd pch W=4u L=0.5u
M28d out28 x28 vdd vdd pch W=4u L=0.5u
M28t tail28 vbias vss vss nch W=4u L=1u
M29a x29 inp29 tail29 vss nch W=2u L=0.5u
M29b out29 inn29 tail29 vss nch W=2u L=0.5u
M29c x29 x29 vdd vdd pch W=4u L=0.5u
M29d out29 x29 vdd vdd pch W=4u L=0.5u
M29t tail29 vbias vss vss nch W=4u L=1u
M30a x30 inp30 tail30 vss nch W=2u L=0.5u
M30b out30 inn30 tail30 vss nch W=2u L=0.5u
M30c x30 x30 vdd vdd pch W=4u L=0.5u
M30d out30 x30 vdd vdd pch W=4u L=0.5u
M30t tail30 vbias vss vss nch W=4u L=1u
M31a x31 inp31 tail31 vss nch W=2u L=0.5u
M31b out31 inn31 tail31 vss nch W=2u L=0.5u
M31c x31 x31 vdd vdd pch W=4u L=0.5u
M31d out31 x31 vdd vdd pch W=4u L=0.5u
M31t tail31 vbias vss vss nch W=4u L=1u
* @RNL {
*   # @SELECT-INSTANCE(model="nch") => @SET-SYMBOL $NMOS;
*   # @SELECT-INSTANCE(model="pch") => @SET-SYMBOL $PMOS;
*   &vdd @ADD-TO $SUPPLY_NET_SET;
*   &vss @ADD-TO $GROUND_NET_SET;
*   %g0 = {#M0a #M0b #M0c #M0d #M0t} @GROUP;
*   %dp0 = #M0a(in_p) #M0b(in_n) #M0t(tail) @AS $DIFFERENTIAL_PAIR;
*   %cm0 = #M0c(ref) #M0d(out) @AS $CURRENT_MIRROR;
*   %axis0 = (_, _);
*   #M0a(a) #M0b(b) %axis0(axis) @AS $MIRRORED;
*   #M0c(a) #M0d(b) %axis0(axis) @AS $MIRRORED;
*   #M0t {#M0a #M0b} @DISTANCE("bottom-to-top", min=2);
*   {#M0a #M0b} {#M0c #M0d} @DISTANCE("bottom-to-top", min=2);
*   %g1 = {#M1a #M1b #M1c #M1d #M1t} @GROUP;
*   %dp1 = #M1a(in_p) #M1b(in_n) #M1t(tail) @AS $DIFFERENTIAL_PAIR;
*   %cm1 = #M1c(ref) #M1d(out) @AS $CURRENT_MIRROR;
*   %axis1 = (_, _);
*   #M1a(a) #M1b(b) %axis1(axis) @AS $MIRRORED;
*   #M1c(a) #M1d(b) %axis1(axis) @AS $MIRRORED;
*   #M1t {#M1a #M1b} @DISTANCE("bottom-to-top", min=2);
*   {#M1a #M1b} {#M1c #M1d} @DISTANCE("bottom-to-top", min=2);
*   %g2 = {#M2a #M2b #M2c #M2d #M2t} @GROUP;
*   %dp2 = #M2a(in_p) #M2b(in_n) #M2t(tail) @AS $DIFFERENTIAL_PAIR;
*   %cm2 = #M2c(ref) #M2d(out) @AS $CURRENT_MIRROR;
*   %axis2 = (_, _);
*   #M2a(a) #M2b(b) %axis2(axis) @AS $MIRRORED;
*   #M2c(a) #M2d(b) %axis2(axis) @AS $MIRRORED;
*   #M2t {#M2a #M2b} @DISTANCE("bottom-to-top", min=2);
*   {#M2a #M2b} {#M2c #M2d} @DISTANCE("bottom-to-top", min=2);
*   %g3 = {#M3a #M3b #M3c #M3d #M3t} @GROUP;
*   %dp3 = #M3a(in_p) #M3b(in_n) #M3t(tail) @AS $DIFFERENTIAL_PAIR;
*   %cm3 = #M3c(ref) #M3d(out) @AS $CURRENT_MIRROR;
*   %axis3 = (_, _);
*   #M3a(a) #M3b(b) %axis3(axis) @AS $MIRRORED;
*   #M3c(a) #M3d(b) %axis3(axis) @AS $MIRRORED;
*   #M3t {#M3a #M3b} @DISTANCE("bottom-to-top", min=2);
*   {#M3a #M3b} {#M3c #M3d} @DISTANCE("bottom-to-top", min=2);
*   %g4 = {#M4a #M4b #M4c #M4d #M4t} @GROUP;
*   %dp4 = #M4a(in_p) #M4b(in_n) #M4t(tail) @AS $DIFFERENTIAL_PAIR;
*   %cm4 = #M4c(ref) #M4d(out) @AS $CURRENT_MIRROR;
*   %axis4 = (_, _);
*   #M4a(a) #M4b(b) %axis4(axis) @AS $MIRRORED;
*   #M4c(a) #M4d(b) %axis4(axis) @AS $MIRRORED;
*   #M4t {#M4a #M4b} @DISTANCE("bottom-to-top", min=2);
*   {#M4a #M4b} {#M4c #M4d} @DISTANCE("bottom-to-top", min=2);
*   %g5 = {#M5a #M5b #M5c #M5d #M5t} @GROUP;
*   %dp5 = #M5a(in_p) #M5b(in_n) #M5t(tail) @AS $DIFFERENTIAL_PAIR;
*   %cm5 = #M5c(ref) #M5d(out) @AS $CURRENT_MIRROR;
*   %axis5 = (_, _);
*   #M5a(a) #M5b(b) %axis5(axis) @AS $MIRRORED;
*   #M5c(a) #M5d(b) %axis5(axis) @AS $MIRRORED;
*   #M5t {#M5a #M5b} @DISTANCE("bottom-to-top", min=2);
*   {#M5a #M5b} {#M5c #M5d} @DISTANCE("bottom-to-top", min=2);
*   %g6 = {#M6a #M6b #M6c #M6d #M6t} @GROUP;
*   %dp6 = #M6a(in_p) #M6b(in_n) #M6t(tail) @AS $DIFFERENTIAL_PAIR;
*   %cm6 = #M6c(ref) #M6d(out) @AS $CURRENT_MIRROR;
*   %axis6 = (_, _);
*   #M6a(a) #M6b(b) %axis6(axis) @AS $MIRRORED;
*   #M6c(a) #M6d(b) %axis6(axis) @AS $MIRRORED;
*   #M6t {#M6a #M6b} @DISTANCE("bottom-to-top", min=2);
*   {#M6a #M6b} {#M6c #M6d} @DISTANCE("bottom-to-top", min=2);
*   %g7 = {#M7a #M7b #M7c #M7d #M7t} @GROUP;
*   %dp7 = #M7a(in_p) #M7b(in_n) #M7t(tail) @AS $DIFFERENTIAL_PAIR;
*   %cm7 = #M7c(ref) #M7d(out) @AS $CURRENT_MIRROR;
*   %axis7 = (_, _);
*   #M7a(a) #M7b(b) %axis7(axis) @AS $MIRRORED;
*   #M7c(a) #M7d(b) %axis7(axis) @AS $MIRRORED;
*   #M7t {#M7a #M7b} @DISTANCE("bottom-to-top", min=2);
*   {#M7a #M7b} {#M7c #M7d} @DISTANCE("bottom-to-top", min=2);
*   %g8 = {#M8a #M8b #M8c #M8d #M8t} @GROUP;
*   %dp8 = #M8a(in_p) #M8b(in_n) #M8t(tail) @AS $DIFFERENTIAL_PAIR;
*   %cm8 = #M8c(ref) #M8d(out) @AS $CURRENT_MIRROR;
*   %axis8 = (_, _);
*   #M8a(a) #M8b(b) %axis8(axis) @AS $MIRRORED;
*   #M8c(a) #M8d(b) %axis8(axis) @AS $MIRRORED;
*   #M8t {#M8a #M8b} @DISTANCE("bottom-to-top", min=2);
*   {#M8a #M8b} {#M8c #M8d} @DISTANCE("bottom-to-top", min=2);
*   %g9 = {#M9a #M9b #M9c #M9d #M9t} @GROUP;
*   %dp9 = #M9a(in_p) #M9b(in_n) #M9t(tail) @AS $DIFFERENTIAL_PAIR;
*   %cm9 = #M9c(ref) #M9d(out) @AS $CURRENT_MIRROR;
*   %axis9 = (_, _);
*   #M9a(a) #M9b(b) %axis9(axis) @AS $MIRRORED;
*   #M9c(a) #M9d(b) %axis9(axis) @AS $MIRRORED;
*   #M9t {#M9a #M9b} @DISTANCE("bottom-to-top", min=2);
*   {#M9a #M9b} {#M9c #M9d} @DISTANCE("bottom-to-top", min=2);
*   %g10 = {#M10a #M10b #M10c #M10d #M10t} @GROUP;
*   %dp10 = #M10a(in_p) #M10b(in_n) #M10t(tail) @AS $DIFFERENTIAL_PAIR;
*   %cm10 = #M10c(ref) #M10d(out) @AS $CURRENT_MIRROR;
*   %axis10 = (_, _);
*   #M10a(a) #M10b(b) %axis10(axis) @AS $MIRRORED;
*   #M10c(a) #M10d(b) %axis10(axis) @AS $MIRRORED;
*   #M10t {#M10a #M10b} @DISTANCE("bottom-to-top", min=2);
*   {#M10a #M10b} {#M10c #M10d} @DISTANCE("bottom-to-top", min=2);
*   %g11 = {#M11a #M11b #M11c #M11d #M11t} @GROUP;
*   %dp11 = #M11a(in_p) #M11b(in_n) #M11t(tail) @AS $DIFFERENTIAL_PAIR;
*   %cm11 = #M11c(ref) #M11d(out) @AS $CURRENT_MIRROR;
*   %axis11 = (_, _);
*   #M11a(a) #M11b(b) %axis11(axis) @AS $MIRRORED;
*   #M11c(a) #M11d(b) %axis11(axis) @AS $MIRRORED;
*   #M11t {#M11a #M11b} @DISTANCE("bottom-to-top", min=2);
*   {#M11a #M11b} {#M11c #M11d} @DISTANCE("bottom-to-top", min=2);
*   %g12 = {#M12a #M12b #M12c #M12d #M12t} @GROUP;
*   %dp12 = #M12a(in_p) #M12b(in_n) #M12t(tail) @AS $DIFFERENTIAL_PAIR;
*   %cm12 = #M12c(ref) #M12d(out) @AS $CURRENT_MIRROR;
*   %axis12 = (_, _);
*   #M12a(a) #M12b(b) %axis12(axis) @AS $MIRRORED;
*   #M12c(a) #M12d(b) %axis12(axis) @AS $MIRRORED;
*   #M12t {#M12a #M12b} @DISTANCE("bottom-to-top", min=2);
*   {#M12a #M12b} {#M12c #M12d} @DISTANCE("bottom-to-top", min=2);
*   %g13 = {#M13a #M13b #M13c #M13d #M13t} @GROUP;
*   %dp13 = #M13a(in_p) #M13b(in_n) #M13t(tail) @AS $DIFFERENTIAL_PAIR;
*   %cm13 = #M13c(ref) #M13d(out) @AS $CURRENT_MIRROR;
*   %axis13 = (_, _);
*   #M13a(a) #M13b(b) %axis13(axis) @AS $MIRRORED;
*   #M13c(a) #M13d(b) %axis13(axis) @AS $MIRRORED;
*   #M13t {#M13a #M13b} @DISTANCE("bottom-to-top", min=2);
*   {#M13a #M13b} {#M13c #M13d} @DISTANCE("bottom-to-top", min=2);
*   %g14 = {#M14a #M14b #M14c #M14d #M14t} @GROUP;
*   %dp14 = #M14a(in_p) #M14b(in_n) #M14t(tail) @AS $DIFFERENTIAL_PAIR;
*   %cm14 = #M14c(ref) #M14d(out) @AS $CURRENT_MIRROR;
*   %axis14 = (_, _);
*   #M14a(a) #M14b(b) %axis14(axis) @AS $MIRRORED;
*   #M14c(a) #M14d(b) %axis14(axis) @AS $MIRRORED;
*   #M14t {#M14a #M14b} @DISTANCE("bottom-to-top", min=2);
*   {#M14a #M14b} {#M14c #M14d} @DISTANCE("bottom-to-top", min=2);
*   %g15 = {#M15a #M15b #M15c #M15d #M15t} @GROUP;
*   %dp15 = #M15a(in_p) #M15b(in_n) #M15t(tail) @AS $DIFFERENTIAL_PAIR;
*   %cm15 = #M15c(ref) #M15d(out) @AS $CURRENT_MIRROR;
*   %axis15 = (_, _);
*   #M15a(a) #M15b(b) %axis15(axis) @AS $MIRRORED;
*   #M15c(a) #M15d(b) %axis15(axis) @AS $MIRRORED;
*   #M15t {#M15a #M15b} @DISTANCE("bottom-to-top", min=2);
*   {#M15a #M15b} {#M15c #M15d} @DISTANCE("bottom-to-top", min=2);
*   %g16 = {#M16a #M16b #M16c #M16d #M16t} @GROUP;
*   %dp16 = #M16a(in_p) #M16b(in_n) #M16t(tail) @AS $DIFFERENTIAL_PAIR;
*   %cm16 = #M16c(ref) #M16d(out) @AS $CURRENT_MIRROR;
*   %axis16 = (_, _);
*   #M16a(a) #M16b(b) %axis16(axis) @AS $MIRRORED;
*   #M16c(a) #M16d(b) %axis16(axis) @AS $MIRRORED;
*   #M16t {#M16a #M16b} @DISTANCE("bottom-to-top", min=2);
*   {#M16a #M16b} {#M16c #M16d} @DISTANCE("bottom-to-top", min=2);
*   %g17 = {#M17a #M17b #M17c #M17d #M17t} @GROUP;
*   %dp17 = #M17a(in_p) #M17b(in_n) #M17t(tail) @AS $DIFFERENTIAL_PAIR;
*   %cm17 = #M17c(ref) #M17d(out) @AS $CURRENT_MIRROR;
*   %axis17 = (_, _);
*   #M17a(a) #M17b(b) %axis17(axis) @AS $MIRRORED;
*   #M17c(a) #M17d(b) %axis17(axis) @AS $MIRRORED;
*   #M17t {#M17a #M17b} @DISTANCE("bottom-to-top", min=2);
*   {#M17a #M17b} {#M17c #M17d} @DISTANCE("bottom-to-top", min=2);
*   %g18 = {#M18a #M18b #M18c #M18d #M18t} @GROUP;
*   %dp18 = #M18a(in_p) #M18b(in_n) #M18t(tail) @AS $DIFFERENTIAL_PAIR;
*   %cm18 = #M18c(ref) #M18d(out) @AS $CURRENT_MIRROR;
*   %axis18 = (_, _);
*   #M18a(a) #M18b(b) %axis18(axis) @AS $MIRRORED;
*   #M18c(a) #M18d(b) %axis18(axis) @AS $MIRRORED;
*   #M18t {#M18a #M18b} @DISTANCE("bottom-to-top", min=2);
*   {#M18a #M18b} {#M18c #M18d} @DISTANCE("bottom-to-top", min=2);
*   %g19 = {#M19a #M19b #M19c #M19d #M19t} @GROUP;
*   %dp19 = #M19a(in_p) #M19b(in_n) #M19t(tail) @AS $DIFFERENTIAL_PAIR;
*   %cm19 = #M19c(ref) #M19d(out) @AS $CURRENT_MIRROR;
*   %axis19 = (_, _);
*   #M19a(a) #M19b(b) %axis19(axis) @AS $MIRRORED;
*   #M19c(a) #M19d(b) %axis19(axis) @AS $MIRRORED;
*   #M19t {#M19a #M19b} @DISTANCE("bottom-to-top", min=2);
*   {#M19a #M19b} {#M19c #M19d} @DISTANCE("bottom-to-top", min=2);
*   %g20 = {#M20a #M20b #M20c #M20d #M20t} @GROUP;
*   %dp20 = #M20a(in_p) #M20b(in_n) #M20t(tail) @AS $DIFFERENTIAL_PAIR;
*   %cm20 = #M20c(ref) #M20d(out) @AS $CURRENT_MIRROR;
*   %axis20 = (_, _);
*   #M20a(a) #M20b(b) %axis20(axis) @AS $MIRRORED;
*   #M20c(a) #M20d(b) %axis20(axis) @AS $MIRRORED;
*   #M20t {#M20a #M20b} @DISTANCE("bottom-to-top", min=2);
*   {#M20a #M20b} {#M20c #M20d} @DISTANCE("bottom-to-top", min=2);
*   %g21 = {#M21a #M21b #M21c #M21d #M21t} @GROUP;
*   %dp21 = #M21a(in_p) #M21b(in_n) #M21t(tail) @AS $DIFFERENTIAL_PAIR;
*   %cm21 = #M21c(ref) #M21d(out) @AS $CURRENT_MIRROR;
*   %axis21 = (_, _);
*   #M21a(a) #M21b(b) %axis21(axis) @AS $MIRRORED;
*   #M21c(a) #M21d(b) %axis21(axis) @AS $MIRRORED;
*   #M21t {#M21a #M21b} @DISTANCE("bottom-to-top", min=2);
*   {#M21a #M21b} {#M21c #M21d} @DISTANCE("bottom-to-top", min=2);
*   %g22 = {#M22a #M22b #M22c #M22d #M22t} @GROUP;
*   %dp22 = #M22a(in_p) #M22b(in_n) #M22t(tail) @AS $DIFFERENTIAL_PAIR;
*   %cm22 = #M22c(ref) #M22d(out) @AS $CURRENT_MIRROR;
*   %axis22 = (_, _);
*   #M22a(a) #M22b(b) %axis22(axis) @AS $MIRRORED;
*   #M22c(a) #M22d(b) %axis22(axis) @AS $MIRRORED;
*   #M22t {#M22a #M22b} @DISTANCE("bottom-to-top", min=2);
*   {#M22a #M22b} {#M22c #M22d} @DISTANCE("bottom-to-top", min=2);
*   %g23 = {#M23a #M23b #M23c #M23d #M23t} @GROUP;
*   %dp23 = #M23a(in_p) #M23b(in_n) #M23t(tail) @AS $DIFFERENTIAL_PAIR;
*   %cm23 = #M23c(ref) #M23d(out) @AS $CURRENT_MIRROR;
*   %axis23 = (_, _);
*   #M23a(a) #M23b(b) %axis23(axis) @AS $MIRRORED;
*   #M23c(a) #M23d(b) %axis23(axis) @AS $MIRRORED;
*   #M23t {#M23a #M23b} @DISTANCE("bottom-to-top", min=2);
*   {#M23a #M23b} {#M23c #M23d} @DISTANCE("bottom-to-top", min=2);
*   %g24 = {#M24a #M24b #M24c #M24d #M24t} @GROUP;
*   %dp24 = #M24a(in_p) #M24b(in_n) #M24t(tail) @AS $DIFFERENTIAL_PAIR;
*   %cm24 = #M24c(ref) #M24d(out) @AS $CURRENT_MIRROR;
*   %axis24 = (_, _);
*   #M24a(a) #M24b(b) %axis24(axis) @AS $MIRRORED;
*   #M24c(a) #M24d(b) %axis24(axis) @AS $MIRRORED;
*   #M24t {#M24a #M24b} @DISTANCE("bottom-to-top", min=2);
*   {#M24a #M24b} {#M24c #M24d} @DISTANCE("bottom-to-top", min=2);
*   %g25 = {#M25a #M25b #M25c #M25d #M25t} @GROUP;
*   %dp25 = #M25a(in_p) #M25b(in_n) #M25t(tail) @AS $DIFFERENTIAL_PAIR;
*   %cm25 = #M25c(ref) #M25d(out) @AS $CURRENT_MIRROR;
*   %axis25 = (_, _);
*   #M25a(a) #M25b(b) %axis25(axis) @AS $MIRRORED;
*   #M25c(a) #M25d(b) %axis25(axis) @AS $MIRRORED;
*   #M25t {#M25a #M25b} @DISTANCE("bottom-to-top", min=2);
*   {#M25a #M25b} {#M25c #M25d} @DISTANCE("bottom-to-top", min=2);
*   %g26 = {#M26a #M26b #M26c #M26d #M26t} @GROUP;
*   %dp26 = #M26a(in_p) #M26b(in_n) #M26t(tail) @AS $DIFFERENTIAL_PAIR;
*   %cm26 = #M26c(ref) #M26d(out) @AS $CURRENT_MIRROR;
*   %axis26 = (_, _);
*   #M26a(a) #M26b(b) %axis26(axis) @AS $MIRRORED;
*   #M26c(a) #M26d(b) %axis26(axis) @AS $MIRRORED;
*   #M26t {#M26a #M26b} @DISTANCE("bottom-to-top", min=2);
*   {#M26a #M26b} {#M26c #M26d} @DISTANCE("bottom-to-top", min=2);
*   %g27 = {#M27a #M27b #M27c #M27d #M27t} @GROUP;
*   %dp27 = #M27a(in_p) #M27b(in_n) #M27t(tail) @AS $DIFFERENTIAL_PAIR;
*   %cm27 = #M27c(ref) #M27d(out) @AS $CURRENT_MIRROR;
*   %axis27 = (_, _);
*   #M27a(a) #M27b(b) %axis27(axis) @AS $MIRRORED;
*   #M27c(a) #M27d(b) %axis27(axis) @AS $MIRRORED;
*   #M27t {#M27a #M27b} @DISTANCE("bottom-to-top", min=2);
*   {#M27a #M27b} {#M27c #M27d} @DISTANCE("bottom-to-top", min=2);
*   %g28 = {#M28a #M28b #M28c #M28d #M28t} @GROUP;
*   %dp28 = #M28a(in_p) #M28b(in_n) #M28t(tail) @AS $DIFFERENTIAL_PAIR;
*   %cm28 = #M28c(ref) #M28d(out) @AS $CURRENT_MIRROR;
*   %axis28 = (_, _);
*   #M28a(a) #M28b(b) %axis28(axis) @AS $MIRRORED;
*   #M28c(a) #M28d(b) %axis28(axis) @AS $MIRRORED;
*   #M28t {#M28a #M28b} @DISTANCE("bottom-to-top", min=2);
*   {#M28a #M28b} {#M28c #M28d} @DISTANCE("bottom-to-top", min=2);
*   %g29 = {#M29a #M29b #M29c #M29d #M29t} @GROUP;
*   %dp29 = #M29a(in_p) #M29b(in_n) #M29t(tail) @AS $DIFFERENTIAL_PAIR;
*   %cm29 = #M29c(ref) #M29d(out) @AS $CURRENT_MIRROR;
*   %axis29 = (_, _);
*   #M29a(a) #M29b(b) %axis29(axis) @AS $MIRRORED;
*   #M29c(a) #M29d(b) %axis29(axis) @AS $MIRRORED;
*   #M29t {#M29a #M29b} @DISTANCE("bottom-to-top", min=2);
*   {#M29a #M29b} {#M29c #M29d} @DISTANCE("bottom-to-top", min=2);
*   %g30 = {#M30a #M30b #M30c #M30d #M30t} @GROUP;
*   %dp30 = #M30a(in_p) #M30b(in_n) #M30t(tail) @AS $DIFFERENTIAL_PAIR;
*   %cm30 = #M30c(ref) #M30d(out) @AS $CURRENT_MIRROR;
*   %axis30 = (_, _);
*   #M30a(a) #M30b(b) %axis30(axis) @AS $MIRRORED;
*   #M30c(a) #M30d(b) %axis30(axis) @AS $MIRRORED;
*   #M30t {#M30a #M30b} @DISTANCE("bottom-to-top", min=2);
*   {#M30a #M30b} {#M30c #M30d} @DISTANCE("bottom-to-top", min=2);
*   %g31 = {#M31a #M31b #M31c #M31d #M31t} @GROUP;
*   %dp31 = #M31a(in_p) #M31b(in_n) #M31t(tail) @AS $DIFFERENTIAL_PAIR;
*   %cm31 = #M31c(ref) #M31d(out) @AS $CURRENT_MIRROR;
*   %axis31 = (_, _);
*   #M31a(a) #M31b(b) %axis31(axis) @AS $MIRRORED;
*   #M31c(a) #M31d(b) %axis31(axis) @AS $MIRRORED;
*   #M31t {#M31a #M31b} @DISTANCE("bottom-to-top", min=2);
*   {#M31a #M31b} {#M31c #M31d} @DISTANCE("bottom-to-top", min=2);
*   {%g0 %g1 %g2 %g3 %g4 %g5 %g6 %g7 %g8 %g9 %g10 %g11 %g12 %g13 %g14 %g15 %g16 %g17 %g18 %g19 %g20 %g21 %g22 %g23 %g24 %g25 %g26 %g27 %g28 %g29 %g30 %g31} @AS $FLOW;
*   $WIRE_NET_SET @ROUTE
* }
.end
