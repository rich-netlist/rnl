* Synthetic diffmirror; n=8; generated by prepare_inputs.py
* @RNL(type="header") { @VERSION("0.3") }
.model nch nmos level=1
.model pch pmos level=1
M0a x0 inp0 tail0 vss nch W=2u L=0.5u
M0b out0 inn0 tail0 vss nch W=2u L=0.5u
M0c x0 x0 vdd vdd pch W=4u L=0.5u
M0d out0 x0 vdd vdd pch W=4u L=0.5u
M0t tail0 vbias vss vss nch W=4u L=1u
M1a x1 inp1 tail1 vss nch W=2u L=0.5u
M1b out1 inn1 tail1 vss nch W=2u L=0.5u
M1c x1 x1 vdd vdd pch W=4u L=0.5u
M1d out1 x1 vdd vdd pch W=4u L=0.5u
M1t tail1 vbias vss vss nch W=4u L=1u
M2a x2 inp2 tail2 vss nch W=2u L=0.5u
M2b out2 inn2 tail2 vss nch W=2u L=0.5u
M2c x2 x2 vdd vdd pch W=4u L=0.5u
M2d out2 x2 vdd vdd pch W=4u L=0.5u
M2t tail2 vbias vss vss nch W=4u L=1u
M3a x3 inp3 tail3 vss nch W=2u L=0.5u
M3b out3 inn3 tail3 vss nch W=2u L=0.5u
M3c x3 x3 vdd vdd pch W=4u L=0.5u
M3d out3 x3 vdd vdd pch W=4u L=0.5u
M3t tail3 vbias vss vss nch W=4u L=1u
M4a x4 inp4 tail4 vss nch W=2u L=0.5u
M4b out4 inn4 tail4 vss nch W=2u L=0.5u
M4c x4 x4 vdd vdd pch W=4u L=0.5u
M4d out4 x4 vdd vdd pch W=4u L=0.5u
M4t tail4 vbias vss vss nch W=4u L=1u
M5a x5 inp5 tail5 vss nch W=2u L=0.5u
M5b out5 inn5 tail5 vss nch W=2u L=0.5u
M5c x5 x5 vdd vdd pch W=4u L=0.5u
M5d out5 x5 vdd vdd pch W=4u L=0.5u
M5t tail5 vbias vss vss nch W=4u L=1u
M6a x6 inp6 tail6 vss nch W=2u L=0.5u
M6b out6 inn6 tail6 vss nch W=2u L=0.5u
M6c x6 x6 vdd vdd pch W=4u L=0.5u
M6d out6 x6 vdd vdd pch W=4u L=0.5u
M6t tail6 vbias vss vss nch W=4u L=1u
M7a x7 inp7 tail7 vss nch W=2u L=0.5u
M7b out7 inn7 tail7 vss nch W=2u L=0.5u
M7c x7 x7 vdd vdd pch W=4u L=0.5u
M7d out7 x7 vdd vdd pch W=4u L=0.5u
M7t tail7 vbias vss vss nch W=4u L=1u
* @RNL {
*   # @SELECT-INSTANCE(model="nch") => @SET-SYMBOL $NMOS;
*   # @SELECT-INSTANCE(model="pch") => @SET-SYMBOL $PMOS;
*   &vdd @ADD-TO $SUPPLY_NET_SET;
*   &vss @ADD-TO $GROUND_NET_SET;
*   %g0 = {#M0a #M0b #M0c #M0d #M0t} @GROUP;
*   %dp0 = #M0a(in_p) #M0b(in_n) #M0t(tail) @AS $DIFFERENTIAL_PAIR;
*   %cm0 = #M0c(ref) #M0d(out) @AS $CURRENT_MIRROR;
*   %axis0 = (_, _);
*   #M0a(a) #M0b(b) %axis0(axis) @AS $MIRRORED;
*   #M0c(a) #M0d(b) %axis0(axis) @AS $MIRRORED;
*   #M0t {#M0a #M0b} @DISTANCE("bottom-to-top", min=2);
*   {#M0a #M0b} {#M0c #M0d} @DISTANCE("bottom-to-top", min=2);
*   %g1 = {#M1a #M1b #M1c #M1d #M1t} @GROUP;
*   %dp1 = #M1a(in_p) #M1b(in_n) #M1t(tail) @AS $DIFFERENTIAL_PAIR;
*   %cm1 = #M1c(ref) #M1d(out) @AS $CURRENT_MIRROR;
*   %axis1 = (_, _);
*   #M1a(a) #M1b(b) %axis1(axis) @AS $MIRRORED;
*   #M1c(a) #M1d(b) %axis1(axis) @AS $MIRRORED;
*   #M1t {#M1a #M1b} @DISTANCE("bottom-to-top", min=2);
*   {#M1a #M1b} {#M1c #M1d} @DISTANCE("bottom-to-top", min=2);
*   %g2 = {#M2a #M2b #M2c #M2d #M2t} @GROUP;
*   %dp2 = #M2a(in_p) #M2b(in_n) #M2t(tail) @AS $DIFFERENTIAL_PAIR;
*   %cm2 = #M2c(ref) #M2d(out) @AS $CURRENT_MIRROR;
*   %axis2 = (_, _);
*   #M2a(a) #M2b(b) %axis2(axis) @AS $MIRRORED;
*   #M2c(a) #M2d(b) %axis2(axis) @AS $MIRRORED;
*   #M2t {#M2a #M2b} @DISTANCE("bottom-to-top", min=2);
*   {#M2a #M2b} {#M2c #M2d} @DISTANCE("bottom-to-top", min=2);
*   %g3 = {#M3a #M3b #M3c #M3d #M3t} @GROUP;
*   %dp3 = #M3a(in_p) #M3b(in_n) #M3t(tail) @AS $DIFFERENTIAL_PAIR;
*   %cm3 = #M3c(ref) #M3d(out) @AS $CURRENT_MIRROR;
*   %axis3 = (_, _);
*   #M3a(a) #M3b(b) %axis3(axis) @AS $MIRRORED;
*   #M3c(a) #M3d(b) %axis3(axis) @AS $MIRRORED;
*   #M3t {#M3a #M3b} @DISTANCE("bottom-to-top", min=2);
*   {#M3a #M3b} {#M3c #M3d} @DISTANCE("bottom-to-top", min=2);
*   %g4 = {#M4a #M4b #M4c #M4d #M4t} @GROUP;
*   %dp4 = #M4a(in_p) #M4b(in_n) #M4t(tail) @AS $DIFFERENTIAL_PAIR;
*   %cm4 = #M4c(ref) #M4d(out) @AS $CURRENT_MIRROR;
*   %axis4 = (_, _);
*   #M4a(a) #M4b(b) %axis4(axis) @AS $MIRRORED;
*   #M4c(a) #M4d(b) %axis4(axis) @AS $MIRRORED;
*   #M4t {#M4a #M4b} @DISTANCE("bottom-to-top", min=2);
*   {#M4a #M4b} {#M4c #M4d} @DISTANCE("bottom-to-top", min=2);
*   %g5 = {#M5a #M5b #M5c #M5d #M5t} @GROUP;
*   %dp5 = #M5a(in_p) #M5b(in_n) #M5t(tail) @AS $DIFFERENTIAL_PAIR;
*   %cm5 = #M5c(ref) #M5d(out) @AS $CURRENT_MIRROR;
*   %axis5 = (_, _);
*   #M5a(a) #M5b(b) %axis5(axis) @AS $MIRRORED;
*   #M5c(a) #M5d(b) %axis5(axis) @AS $MIRRORED;
*   #M5t {#M5a #M5b} @DISTANCE("bottom-to-top", min=2);
*   {#M5a #M5b} {#M5c #M5d} @DISTANCE("bottom-to-top", min=2);
*   %g6 = {#M6a #M6b #M6c #M6d #M6t} @GROUP;
*   %dp6 = #M6a(in_p) #M6b(in_n) #M6t(tail) @AS $DIFFERENTIAL_PAIR;
*   %cm6 = #M6c(ref) #M6d(out) @AS $CURRENT_MIRROR;
*   %axis6 = (_, _);
*   #M6a(a) #M6b(b) %axis6(axis) @AS $MIRRORED;
*   #M6c(a) #M6d(b) %axis6(axis) @AS $MIRRORED;
*   #M6t {#M6a #M6b} @DISTANCE("bottom-to-top", min=2);
*   {#M6a #M6b} {#M6c #M6d} @DISTANCE("bottom-to-top", min=2);
*   %g7 = {#M7a #M7b #M7c #M7d #M7t} @GROUP;
*   %dp7 = #M7a(in_p) #M7b(in_n) #M7t(tail) @AS $DIFFERENTIAL_PAIR;
*   %cm7 = #M7c(ref) #M7d(out) @AS $CURRENT_MIRROR;
*   %axis7 = (_, _);
*   #M7a(a) #M7b(b) %axis7(axis) @AS $MIRRORED;
*   #M7c(a) #M7d(b) %axis7(axis) @AS $MIRRORED;
*   #M7t {#M7a #M7b} @DISTANCE("bottom-to-top", min=2);
*   {#M7a #M7b} {#M7c #M7d} @DISTANCE("bottom-to-top", min=2);
*   {%g0 %g1 %g2 %g3 %g4 %g5 %g6 %g7} @AS $FLOW;
*   $WIRE_NET_SET @ROUTE
* }
.end
