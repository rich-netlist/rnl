* Synthetic diffmirror; n=128; generated by prepare_inputs.py
* @RNL(type="header") { @VERSION("0.3") }
.model nch nmos level=1
.model pch pmos level=1
M0a x0 inp0 tail0 vss nch W=2u L=0.5u
M0b out0 inn0 tail0 vss nch W=2u L=0.5u
M0c x0 x0 vdd vdd pch W=4u L=0.5u
M0d out0 x0 vdd vdd pch W=4u L=0.5u
M0t tail0 vbias vss vss nch W=4u L=1u
M1a x1 inp1 tail1 vss nch W=2u L=0.5u
M1b out1 inn1 tail1 vss nch W=2u L=0.5u
M1c x1 x1 vdd vdd pch W=4u L=0.5u
M1d out1 x1 vdd vdd pch W=4u L=0.5u
M1t tail1 vbias vss vss nch W=4u L=1u
M2a x2 inp2 tail2 vss nch W=2u L=0.5u
M2b out2 inn2 tail2 vss nch W=2u L=0.5u
M2c x2 x2 vdd vdd pch W=4u L=0.5u
M2d out2 x2 vdd vdd pch W=4u L=0.5u
M2t tail2 vbias vss vss nch W=4u L=1u
M3a x3 inp3 tail3 vss nch W=2u L=0.5u
M3b out3 inn3 tail3 vss nch W=2u L=0.5u
M3c x3 x3 vdd vdd pch W=4u L=0.5u
M3d out3 x3 vdd vdd pch W=4u L=0.5u
M3t tail3 vbias vss vss nch W=4u L=1u
M4a x4 inp4 tail4 vss nch W=2u L=0.5u
M4b out4 inn4 tail4 vss nch W=2u L=0.5u
M4c x4 x4 vdd vdd pch W=4u L=0.5u
M4d out4 x4 vdd vdd pch W=4u L=0.5u
M4t tail4 vbias vss vss nch W=4u L=1u
M5a x5 inp5 tail5 vss nch W=2u L=0.5u
M5b out5 inn5 tail5 vss nch W=2u L=0.5u
M5c x5 x5 vdd vdd pch W=4u L=0.5u
M5d out5 x5 vdd vdd pch W=4u L=0.5u
M5t tail5 vbias vss vss nch W=4u L=1u
M6a x6 inp6 tail6 vss nch W=2u L=0.5u
M6b out6 inn6 tail6 vss nch W=2u L=0.5u
M6c x6 x6 vdd vdd pch W=4u L=0.5u
M6d out6 x6 vdd vdd pch W=4u L=0.5u
M6t tail6 vbias vss vss nch W=4u L=1u
M7a x7 inp7 tail7 vss nch W=2u L=0.5u
M7b out7 inn7 tail7 vss nch W=2u L=0.5u
M7c x7 x7 vdd vdd pch W=4u L=0.5u
M7d out7 x7 vdd vdd pch W=4u L=0.5u
M7t tail7 vbias vss vss nch W=4u L=1u
M8a x8 inp8 tail8 vss nch W=2u L=0.5u
M8b out8 inn8 tail8 vss nch W=2u L=0.5u
M8c x8 x8 vdd vdd pch W=4u L=0.5u
M8d out8 x8 vdd vdd pch W=4u L=0.5u
M8t tail8 vbias vss vss nch W=4u L=1u
M9a x9 inp9 tail9 vss nch W=2u L=0.5u
M9b out9 inn9 tail9 vss nch W=2u L=0.5u
M9c x9 x9 vdd vdd pch W=4u L=0.5u
M9d out9 x9 vdd vdd pch W=4u L=0.5u
M9t tail9 vbias vss vss nch W=4u L=1u
M10a x10 inp10 tail10 vss nch W=2u L=0.5u
M10b out10 inn10 tail10 vss nch W=2u L=0.5u
M10c x10 x10 vdd vdd pch W=4u L=0.5u
M10d out10 x10 vdd vdd pch W=4u L=0.5u
M10t tail10 vbias vss vss nch W=4u L=1u
M11a x11 inp11 tail11 vss nch W=2u L=0.5u
M11b out11 inn11 tail11 vss nch W=2u L=0.5u
M11c x11 x11 vdd vdd pch W=4u L=0.5u
M11d out11 x11 vdd vdd pch W=4u L=0.5u
M11t tail11 vbias vss vss nch W=4u L=1u
M12a x12 inp12 tail12 vss nch W=2u L=0.5u
M12b out12 inn12 tail12 vss nch W=2u L=0.5u
M12c x12 x12 vdd vdd pch W=4u L=0.5u
M12d out12 x12 vdd vdd pch W=4u L=0.5u
M12t tail12 vbias vss vss nch W=4u L=1u
M13a x13 inp13 tail13 vss nch W=2u L=0.5u
M13b out13 inn13 tail13 vss nch W=2u L=0.5u
M13c x13 x13 vdd vdd pch W=4u L=0.5u
M13d out13 x13 vdd vdd pch W=4u L=0.5u
M13t tail13 vbias vss vss nch W=4u L=1u
M14a x14 inp14 tail14 vss nch W=2u L=0.5u
M14b out14 inn14 tail14 vss nch W=2u L=0.5u
M14c x14 x14 vdd vdd pch W=4u L=0.5u
M14d out14 x14 vdd vdd pch W=4u L=0.5u
M14t tail14 vbias vss vss nch W=4u L=1u
M15a x15 inp15 tail15 vss nch W=2u L=0.5u
M15b out15 inn15 tail15 vss nch W=2u L=0.5u
M15c x15 x15 vdd vdd pch W=4u L=0.5u
M15d out15 x15 vdd vdd pch W=4u L=0.5u
M15t tail15 vbias vss vss nch W=4u L=1u
M16a x16 inp16 tail16 vss nch W=2u L=0.5u
M16b out16 inn16 tail16 vss nch W=2u L=0.5u
M16c x16 x16 vdd vdd pch W=4u L=0.5u
M16d out16 x16 vdd vdd pch W=4u L=0.5u
M16t tail16 vbias vss vss nch W=4u L=1u
M17a x17 inp17 tail17 vss nch W=2u L=0.5u
M17b out17 inn17 tail17 vss nch W=2u L=0.5u
M17c x17 x17 vdd vdd pch W=4u L=0.5u
M17d out17 x17 vdd vdd pch W=4u L=0.5u
M17t tail17 vbias vss vss nch W=4u L=1u
M18a x18 inp18 tail18 vss nch W=2u L=0.5u
M18b out18 inn18 tail18 vss nch W=2u L=0.5u
M18c x18 x18 vdd vdd pch W=4u L=0.5u
M18d out18 x18 vdd vdd pch W=4u L=0.5u
M18t tail18 vbias vss vss nch W=4u L=1u
M19a x19 inp19 tail19 vss nch W=2u L=0.5u
M19b out19 inn19 tail19 vss nch W=2u L=0.5u
M19c x19 x19 vdd vdd pch W=4u L=0.5u
M19d out19 x19 vdd vdd pch W=4u L=0.5u
M19t tail19 vbias vss vss nch W=4u L=1u
M20a x20 inp20 tail20 vss nch W=2u L=0.5u
M20b out20 inn20 tail20 vss nch W=2u L=0.5u
M20c x20 x20 vdd vdd pch W=4u L=0.5u
M20d out20 x20 vdd vdd pch W=4u L=0.5u
M20t tail20 vbias vss vss nch W=4u L=1u
M21a x21 inp21 tail21 vss nch W=2u L=0.5u
M21b out21 inn21 tail21 vss nch W=2u L=0.5u
M21c x21 x21 vdd vdd pch W=4u L=0.5u
M21d out21 x21 vdd vdd pch W=4u L=0.5u
M21t tail21 vbias vss vss nch W=4u L=1u
M22a x22 inp22 tail22 vss nch W=2u L=0.5u
M22b out22 inn22 tail22 vss nch W=2u L=0.5u
M22c x22 x22 vdd vdd pch W=4u L=0.5u
M22d out22 x22 vdd vdd pch W=4u L=0.5u
M22t tail22 vbias vss vss nch W=4u L=1u
M23a x23 inp23 tail23 vss nch W=2u L=0.5u
M23b out23 inn23 tail23 vss nch W=2u L=0.5u
M23c x23 x23 vdd vdd pch W=4u L=0.5u
M23d out23 x23 vdd vdd pch W=4u L=0.5u
M23t tail23 vbias vss vss nch W=4u L=1u
M24a x24 inp24 tail24 vss nch W=2u L=0.5u
M24b out24 inn24 tail24 vss nch W=2u L=0.5u
M24c x24 x24 vdd vdd pch W=4u L=0.5u
M24d out24 x24 vdd vdd pch W=4u L=0.5u
M24t tail24 vbias vss vss nch W=4u L=1u
M25a x25 inp25 tail25 vss nch W=2u L=0.5u
M25b out25 inn25 tail25 vss nch W=2u L=0.5u
M25c x25 x25 vdd vdd pch W=4u L=0.5u
M25d out25 x25 vdd vdd pch W=4u L=0.5u
M25t tail25 vbias vss vss nch W=4u L=1u
M26a x26 inp26 tail26 vss nch W=2u L=0.5u
M26b out26 inn26 tail26 vss nch W=2u L=0.5u
M26c x26 x26 vdd vdd pch W=4u L=0.5u
M26d out26 x26 vdd vdd pch W=4u L=0.5u
M26t tail26 vbias vss vss nch W=4u L=1u
M27a x27 inp27 tail27 vss nch W=2u L=0.5u
M27b out27 inn27 tail27 vss nch W=2u L=0.5u
M27c x27 x27 vdd vdd pch W=4u L=0.5u
M27d out27 x27 vdd vdd pch W=4u L=0.5u
M27t tail27 vbias vss vss nch W=4u L=1u
M28a x28 inp28 tail28 vss nch W=2u L=0.5u
M28b out28 inn28 tail28 vss nch W=2u L=0.5u
M28c x28 x28 vdd vdd pch W=4u L=0.5u
M28d out28 x28 vdd vdd pch W=4u L=0.5u
M28t tail28 vbias vss vss nch W=4u L=1u
M29a x29 inp29 tail29 vss nch W=2u L=0.5u
M29b out29 inn29 tail29 vss nch W=2u L=0.5u
M29c x29 x29 vdd vdd pch W=4u L=0.5u
M29d out29 x29 vdd vdd pch W=4u L=0.5u
M29t tail29 vbias vss vss nch W=4u L=1u
M30a x30 inp30 tail30 vss nch W=2u L=0.5u
M30b out30 inn30 tail30 vss nch W=2u L=0.5u
M30c x30 x30 vdd vdd pch W=4u L=0.5u
M30d out30 x30 vdd vdd pch W=4u L=0.5u
M30t tail30 vbias vss vss nch W=4u L=1u
M31a x31 inp31 tail31 vss nch W=2u L=0.5u
M31b out31 inn31 tail31 vss nch W=2u L=0.5u
M31c x31 x31 vdd vdd pch W=4u L=0.5u
M31d out31 x31 vdd vdd pch W=4u L=0.5u
M31t tail31 vbias vss vss nch W=4u L=1u
M32a x32 inp32 tail32 vss nch W=2u L=0.5u
M32b out32 inn32 tail32 vss nch W=2u L=0.5u
M32c x32 x32 vdd vdd pch W=4u L=0.5u
M32d out32 x32 vdd vdd pch W=4u L=0.5u
M32t tail32 vbias vss vss nch W=4u L=1u
M33a x33 inp33 tail33 vss nch W=2u L=0.5u
M33b out33 inn33 tail33 vss nch W=2u L=0.5u
M33c x33 x33 vdd vdd pch W=4u L=0.5u
M33d out33 x33 vdd vdd pch W=4u L=0.5u
M33t tail33 vbias vss vss nch W=4u L=1u
M34a x34 inp34 tail34 vss nch W=2u L=0.5u
M34b out34 inn34 tail34 vss nch W=2u L=0.5u
M34c x34 x34 vdd vdd pch W=4u L=0.5u
M34d out34 x34 vdd vdd pch W=4u L=0.5u
M34t tail34 vbias vss vss nch W=4u L=1u
M35a x35 inp35 tail35 vss nch W=2u L=0.5u
M35b out35 inn35 tail35 vss nch W=2u L=0.5u
M35c x35 x35 vdd vdd pch W=4u L=0.5u
M35d out35 x35 vdd vdd pch W=4u L=0.5u
M35t tail35 vbias vss vss nch W=4u L=1u
M36a x36 inp36 tail36 vss nch W=2u L=0.5u
M36b out36 inn36 tail36 vss nch W=2u L=0.5u
M36c x36 x36 vdd vdd pch W=4u L=0.5u
M36d out36 x36 vdd vdd pch W=4u L=0.5u
M36t tail36 vbias vss vss nch W=4u L=1u
M37a x37 inp37 tail37 vss nch W=2u L=0.5u
M37b out37 inn37 tail37 vss nch W=2u L=0.5u
M37c x37 x37 vdd vdd pch W=4u L=0.5u
M37d out37 x37 vdd vdd pch W=4u L=0.5u
M37t tail37 vbias vss vss nch W=4u L=1u
M38a x38 inp38 tail38 vss nch W=2u L=0.5u
M38b out38 inn38 tail38 vss nch W=2u L=0.5u
M38c x38 x38 vdd vdd pch W=4u L=0.5u
M38d out38 x38 vdd vdd pch W=4u L=0.5u
M38t tail38 vbias vss vss nch W=4u L=1u
M39a x39 inp39 tail39 vss nch W=2u L=0.5u
M39b out39 inn39 tail39 vss nch W=2u L=0.5u
M39c x39 x39 vdd vdd pch W=4u L=0.5u
M39d out39 x39 vdd vdd pch W=4u L=0.5u
M39t tail39 vbias vss vss nch W=4u L=1u
M40a x40 inp40 tail40 vss nch W=2u L=0.5u
M40b out40 inn40 tail40 vss nch W=2u L=0.5u
M40c x40 x40 vdd vdd pch W=4u L=0.5u
M40d out40 x40 vdd vdd pch W=4u L=0.5u
M40t tail40 vbias vss vss nch W=4u L=1u
M41a x41 inp41 tail41 vss nch W=2u L=0.5u
M41b out41 inn41 tail41 vss nch W=2u L=0.5u
M41c x41 x41 vdd vdd pch W=4u L=0.5u
M41d out41 x41 vdd vdd pch W=4u L=0.5u
M41t tail41 vbias vss vss nch W=4u L=1u
M42a x42 inp42 tail42 vss nch W=2u L=0.5u
M42b out42 inn42 tail42 vss nch W=2u L=0.5u
M42c x42 x42 vdd vdd pch W=4u L=0.5u
M42d out42 x42 vdd vdd pch W=4u L=0.5u
M42t tail42 vbias vss vss nch W=4u L=1u
M43a x43 inp43 tail43 vss nch W=2u L=0.5u
M43b out43 inn43 tail43 vss nch W=2u L=0.5u
M43c x43 x43 vdd vdd pch W=4u L=0.5u
M43d out43 x43 vdd vdd pch W=4u L=0.5u
M43t tail43 vbias vss vss nch W=4u L=1u
M44a x44 inp44 tail44 vss nch W=2u L=0.5u
M44b out44 inn44 tail44 vss nch W=2u L=0.5u
M44c x44 x44 vdd vdd pch W=4u L=0.5u
M44d out44 x44 vdd vdd pch W=4u L=0.5u
M44t tail44 vbias vss vss nch W=4u L=1u
M45a x45 inp45 tail45 vss nch W=2u L=0.5u
M45b out45 inn45 tail45 vss nch W=2u L=0.5u
M45c x45 x45 vdd vdd pch W=4u L=0.5u
M45d out45 x45 vdd vdd pch W=4u L=0.5u
M45t tail45 vbias vss vss nch W=4u L=1u
M46a x46 inp46 tail46 vss nch W=2u L=0.5u
M46b out46 inn46 tail46 vss nch W=2u L=0.5u
M46c x46 x46 vdd vdd pch W=4u L=0.5u
M46d out46 x46 vdd vdd pch W=4u L=0.5u
M46t tail46 vbias vss vss nch W=4u L=1u
M47a x47 inp47 tail47 vss nch W=2u L=0.5u
M47b out47 inn47 tail47 vss nch W=2u L=0.5u
M47c x47 x47 vdd vdd pch W=4u L=0.5u
M47d out47 x47 vdd vdd pch W=4u L=0.5u
M47t tail47 vbias vss vss nch W=4u L=1u
M48a x48 inp48 tail48 vss nch W=2u L=0.5u
M48b out48 inn48 tail48 vss nch W=2u L=0.5u
M48c x48 x48 vdd vdd pch W=4u L=0.5u
M48d out48 x48 vdd vdd pch W=4u L=0.5u
M48t tail48 vbias vss vss nch W=4u L=1u
M49a x49 inp49 tail49 vss nch W=2u L=0.5u
M49b out49 inn49 tail49 vss nch W=2u L=0.5u
M49c x49 x49 vdd vdd pch W=4u L=0.5u
M49d out49 x49 vdd vdd pch W=4u L=0.5u
M49t tail49 vbias vss vss nch W=4u L=1u
M50a x50 inp50 tail50 vss nch W=2u L=0.5u
M50b out50 inn50 tail50 vss nch W=2u L=0.5u
M50c x50 x50 vdd vdd pch W=4u L=0.5u
M50d out50 x50 vdd vdd pch W=4u L=0.5u
M50t tail50 vbias vss vss nch W=4u L=1u
M51a x51 inp51 tail51 vss nch W=2u L=0.5u
M51b out51 inn51 tail51 vss nch W=2u L=0.5u
M51c x51 x51 vdd vdd pch W=4u L=0.5u
M51d out51 x51 vdd vdd pch W=4u L=0.5u
M51t tail51 vbias vss vss nch W=4u L=1u
M52a x52 inp52 tail52 vss nch W=2u L=0.5u
M52b out52 inn52 tail52 vss nch W=2u L=0.5u
M52c x52 x52 vdd vdd pch W=4u L=0.5u
M52d out52 x52 vdd vdd pch W=4u L=0.5u
M52t tail52 vbias vss vss nch W=4u L=1u
M53a x53 inp53 tail53 vss nch W=2u L=0.5u
M53b out53 inn53 tail53 vss nch W=2u L=0.5u
M53c x53 x53 vdd vdd pch W=4u L=0.5u
M53d out53 x53 vdd vdd pch W=4u L=0.5u
M53t tail53 vbias vss vss nch W=4u L=1u
M54a x54 inp54 tail54 vss nch W=2u L=0.5u
M54b out54 inn54 tail54 vss nch W=2u L=0.5u
M54c x54 x54 vdd vdd pch W=4u L=0.5u
M54d out54 x54 vdd vdd pch W=4u L=0.5u
M54t tail54 vbias vss vss nch W=4u L=1u
M55a x55 inp55 tail55 vss nch W=2u L=0.5u
M55b out55 inn55 tail55 vss nch W=2u L=0.5u
M55c x55 x55 vdd vdd pch W=4u L=0.5u
M55d out55 x55 vdd vdd pch W=4u L=0.5u
M55t tail55 vbias vss vss nch W=4u L=1u
M56a x56 inp56 tail56 vss nch W=2u L=0.5u
M56b out56 inn56 tail56 vss nch W=2u L=0.5u
M56c x56 x56 vdd vdd pch W=4u L=0.5u
M56d out56 x56 vdd vdd pch W=4u L=0.5u
M56t tail56 vbias vss vss nch W=4u L=1u
M57a x57 inp57 tail57 vss nch W=2u L=0.5u
M57b out57 inn57 tail57 vss nch W=2u L=0.5u
M57c x57 x57 vdd vdd pch W=4u L=0.5u
M57d out57 x57 vdd vdd pch W=4u L=0.5u
M57t tail57 vbias vss vss nch W=4u L=1u
M58a x58 inp58 tail58 vss nch W=2u L=0.5u
M58b out58 inn58 tail58 vss nch W=2u L=0.5u
M58c x58 x58 vdd vdd pch W=4u L=0.5u
M58d out58 x58 vdd vdd pch W=4u L=0.5u
M58t tail58 vbias vss vss nch W=4u L=1u
M59a x59 inp59 tail59 vss nch W=2u L=0.5u
M59b out59 inn59 tail59 vss nch W=2u L=0.5u
M59c x59 x59 vdd vdd pch W=4u L=0.5u
M59d out59 x59 vdd vdd pch W=4u L=0.5u
M59t tail59 vbias vss vss nch W=4u L=1u
M60a x60 inp60 tail60 vss nch W=2u L=0.5u
M60b out60 inn60 tail60 vss nch W=2u L=0.5u
M60c x60 x60 vdd vdd pch W=4u L=0.5u
M60d out60 x60 vdd vdd pch W=4u L=0.5u
M60t tail60 vbias vss vss nch W=4u L=1u
M61a x61 inp61 tail61 vss nch W=2u L=0.5u
M61b out61 inn61 tail61 vss nch W=2u L=0.5u
M61c x61 x61 vdd vdd pch W=4u L=0.5u
M61d out61 x61 vdd vdd pch W=4u L=0.5u
M61t tail61 vbias vss vss nch W=4u L=1u
M62a x62 inp62 tail62 vss nch W=2u L=0.5u
M62b out62 inn62 tail62 vss nch W=2u L=0.5u
M62c x62 x62 vdd vdd pch W=4u L=0.5u
M62d out62 x62 vdd vdd pch W=4u L=0.5u
M62t tail62 vbias vss vss nch W=4u L=1u
M63a x63 inp63 tail63 vss nch W=2u L=0.5u
M63b out63 inn63 tail63 vss nch W=2u L=0.5u
M63c x63 x63 vdd vdd pch W=4u L=0.5u
M63d out63 x63 vdd vdd pch W=4u L=0.5u
M63t tail63 vbias vss vss nch W=4u L=1u
M64a x64 inp64 tail64 vss nch W=2u L=0.5u
M64b out64 inn64 tail64 vss nch W=2u L=0.5u
M64c x64 x64 vdd vdd pch W=4u L=0.5u
M64d out64 x64 vdd vdd pch W=4u L=0.5u
M64t tail64 vbias vss vss nch W=4u L=1u
M65a x65 inp65 tail65 vss nch W=2u L=0.5u
M65b out65 inn65 tail65 vss nch W=2u L=0.5u
M65c x65 x65 vdd vdd pch W=4u L=0.5u
M65d out65 x65 vdd vdd pch W=4u L=0.5u
M65t tail65 vbias vss vss nch W=4u L=1u
M66a x66 inp66 tail66 vss nch W=2u L=0.5u
M66b out66 inn66 tail66 vss nch W=2u L=0.5u
M66c x66 x66 vdd vdd pch W=4u L=0.5u
M66d out66 x66 vdd vdd pch W=4u L=0.5u
M66t tail66 vbias vss vss nch W=4u L=1u
M67a x67 inp67 tail67 vss nch W=2u L=0.5u
M67b out67 inn67 tail67 vss nch W=2u L=0.5u
M67c x67 x67 vdd vdd pch W=4u L=0.5u
M67d out67 x67 vdd vdd pch W=4u L=0.5u
M67t tail67 vbias vss vss nch W=4u L=1u
M68a x68 inp68 tail68 vss nch W=2u L=0.5u
M68b out68 inn68 tail68 vss nch W=2u L=0.5u
M68c x68 x68 vdd vdd pch W=4u L=0.5u
M68d out68 x68 vdd vdd pch W=4u L=0.5u
M68t tail68 vbias vss vss nch W=4u L=1u
M69a x69 inp69 tail69 vss nch W=2u L=0.5u
M69b out69 inn69 tail69 vss nch W=2u L=0.5u
M69c x69 x69 vdd vdd pch W=4u L=0.5u
M69d out69 x69 vdd vdd pch W=4u L=0.5u
M69t tail69 vbias vss vss nch W=4u L=1u
M70a x70 inp70 tail70 vss nch W=2u L=0.5u
M70b out70 inn70 tail70 vss nch W=2u L=0.5u
M70c x70 x70 vdd vdd pch W=4u L=0.5u
M70d out70 x70 vdd vdd pch W=4u L=0.5u
M70t tail70 vbias vss vss nch W=4u L=1u
M71a x71 inp71 tail71 vss nch W=2u L=0.5u
M71b out71 inn71 tail71 vss nch W=2u L=0.5u
M71c x71 x71 vdd vdd pch W=4u L=0.5u
M71d out71 x71 vdd vdd pch W=4u L=0.5u
M71t tail71 vbias vss vss nch W=4u L=1u
M72a x72 inp72 tail72 vss nch W=2u L=0.5u
M72b out72 inn72 tail72 vss nch W=2u L=0.5u
M72c x72 x72 vdd vdd pch W=4u L=0.5u
M72d out72 x72 vdd vdd pch W=4u L=0.5u
M72t tail72 vbias vss vss nch W=4u L=1u
M73a x73 inp73 tail73 vss nch W=2u L=0.5u
M73b out73 inn73 tail73 vss nch W=2u L=0.5u
M73c x73 x73 vdd vdd pch W=4u L=0.5u
M73d out73 x73 vdd vdd pch W=4u L=0.5u
M73t tail73 vbias vss vss nch W=4u L=1u
M74a x74 inp74 tail74 vss nch W=2u L=0.5u
M74b out74 inn74 tail74 vss nch W=2u L=0.5u
M74c x74 x74 vdd vdd pch W=4u L=0.5u
M74d out74 x74 vdd vdd pch W=4u L=0.5u
M74t tail74 vbias vss vss nch W=4u L=1u
M75a x75 inp75 tail75 vss nch W=2u L=0.5u
M75b out75 inn75 tail75 vss nch W=2u L=0.5u
M75c x75 x75 vdd vdd pch W=4u L=0.5u
M75d out75 x75 vdd vdd pch W=4u L=0.5u
M75t tail75 vbias vss vss nch W=4u L=1u
M76a x76 inp76 tail76 vss nch W=2u L=0.5u
M76b out76 inn76 tail76 vss nch W=2u L=0.5u
M76c x76 x76 vdd vdd pch W=4u L=0.5u
M76d out76 x76 vdd vdd pch W=4u L=0.5u
M76t tail76 vbias vss vss nch W=4u L=1u
M77a x77 inp77 tail77 vss nch W=2u L=0.5u
M77b out77 inn77 tail77 vss nch W=2u L=0.5u
M77c x77 x77 vdd vdd pch W=4u L=0.5u
M77d out77 x77 vdd vdd pch W=4u L=0.5u
M77t tail77 vbias vss vss nch W=4u L=1u
M78a x78 inp78 tail78 vss nch W=2u L=0.5u
M78b out78 inn78 tail78 vss nch W=2u L=0.5u
M78c x78 x78 vdd vdd pch W=4u L=0.5u
M78d out78 x78 vdd vdd pch W=4u L=0.5u
M78t tail78 vbias vss vss nch W=4u L=1u
M79a x79 inp79 tail79 vss nch W=2u L=0.5u
M79b out79 inn79 tail79 vss nch W=2u L=0.5u
M79c x79 x79 vdd vdd pch W=4u L=0.5u
M79d out79 x79 vdd vdd pch W=4u L=0.5u
M79t tail79 vbias vss vss nch W=4u L=1u
M80a x80 inp80 tail80 vss nch W=2u L=0.5u
M80b out80 inn80 tail80 vss nch W=2u L=0.5u
M80c x80 x80 vdd vdd pch W=4u L=0.5u
M80d out80 x80 vdd vdd pch W=4u L=0.5u
M80t tail80 vbias vss vss nch W=4u L=1u
M81a x81 inp81 tail81 vss nch W=2u L=0.5u
M81b out81 inn81 tail81 vss nch W=2u L=0.5u
M81c x81 x81 vdd vdd pch W=4u L=0.5u
M81d out81 x81 vdd vdd pch W=4u L=0.5u
M81t tail81 vbias vss vss nch W=4u L=1u
M82a x82 inp82 tail82 vss nch W=2u L=0.5u
M82b out82 inn82 tail82 vss nch W=2u L=0.5u
M82c x82 x82 vdd vdd pch W=4u L=0.5u
M82d out82 x82 vdd vdd pch W=4u L=0.5u
M82t tail82 vbias vss vss nch W=4u L=1u
M83a x83 inp83 tail83 vss nch W=2u L=0.5u
M83b out83 inn83 tail83 vss nch W=2u L=0.5u
M83c x83 x83 vdd vdd pch W=4u L=0.5u
M83d out83 x83 vdd vdd pch W=4u L=0.5u
M83t tail83 vbias vss vss nch W=4u L=1u
M84a x84 inp84 tail84 vss nch W=2u L=0.5u
M84b out84 inn84 tail84 vss nch W=2u L=0.5u
M84c x84 x84 vdd vdd pch W=4u L=0.5u
M84d out84 x84 vdd vdd pch W=4u L=0.5u
M84t tail84 vbias vss vss nch W=4u L=1u
M85a x85 inp85 tail85 vss nch W=2u L=0.5u
M85b out85 inn85 tail85 vss nch W=2u L=0.5u
M85c x85 x85 vdd vdd pch W=4u L=0.5u
M85d out85 x85 vdd vdd pch W=4u L=0.5u
M85t tail85 vbias vss vss nch W=4u L=1u
M86a x86 inp86 tail86 vss nch W=2u L=0.5u
M86b out86 inn86 tail86 vss nch W=2u L=0.5u
M86c x86 x86 vdd vdd pch W=4u L=0.5u
M86d out86 x86 vdd vdd pch W=4u L=0.5u
M86t tail86 vbias vss vss nch W=4u L=1u
M87a x87 inp87 tail87 vss nch W=2u L=0.5u
M87b out87 inn87 tail87 vss nch W=2u L=0.5u
M87c x87 x87 vdd vdd pch W=4u L=0.5u
M87d out87 x87 vdd vdd pch W=4u L=0.5u
M87t tail87 vbias vss vss nch W=4u L=1u
M88a x88 inp88 tail88 vss nch W=2u L=0.5u
M88b out88 inn88 tail88 vss nch W=2u L=0.5u
M88c x88 x88 vdd vdd pch W=4u L=0.5u
M88d out88 x88 vdd vdd pch W=4u L=0.5u
M88t tail88 vbias vss vss nch W=4u L=1u
M89a x89 inp89 tail89 vss nch W=2u L=0.5u
M89b out89 inn89 tail89 vss nch W=2u L=0.5u
M89c x89 x89 vdd vdd pch W=4u L=0.5u
M89d out89 x89 vdd vdd pch W=4u L=0.5u
M89t tail89 vbias vss vss nch W=4u L=1u
M90a x90 inp90 tail90 vss nch W=2u L=0.5u
M90b out90 inn90 tail90 vss nch W=2u L=0.5u
M90c x90 x90 vdd vdd pch W=4u L=0.5u
M90d out90 x90 vdd vdd pch W=4u L=0.5u
M90t tail90 vbias vss vss nch W=4u L=1u
M91a x91 inp91 tail91 vss nch W=2u L=0.5u
M91b out91 inn91 tail91 vss nch W=2u L=0.5u
M91c x91 x91 vdd vdd pch W=4u L=0.5u
M91d out91 x91 vdd vdd pch W=4u L=0.5u
M91t tail91 vbias vss vss nch W=4u L=1u
M92a x92 inp92 tail92 vss nch W=2u L=0.5u
M92b out92 inn92 tail92 vss nch W=2u L=0.5u
M92c x92 x92 vdd vdd pch W=4u L=0.5u
M92d out92 x92 vdd vdd pch W=4u L=0.5u
M92t tail92 vbias vss vss nch W=4u L=1u
M93a x93 inp93 tail93 vss nch W=2u L=0.5u
M93b out93 inn93 tail93 vss nch W=2u L=0.5u
M93c x93 x93 vdd vdd pch W=4u L=0.5u
M93d out93 x93 vdd vdd pch W=4u L=0.5u
M93t tail93 vbias vss vss nch W=4u L=1u
M94a x94 inp94 tail94 vss nch W=2u L=0.5u
M94b out94 inn94 tail94 vss nch W=2u L=0.5u
M94c x94 x94 vdd vdd pch W=4u L=0.5u
M94d out94 x94 vdd vdd pch W=4u L=0.5u
M94t tail94 vbias vss vss nch W=4u L=1u
M95a x95 inp95 tail95 vss nch W=2u L=0.5u
M95b out95 inn95 tail95 vss nch W=2u L=0.5u
M95c x95 x95 vdd vdd pch W=4u L=0.5u
M95d out95 x95 vdd vdd pch W=4u L=0.5u
M95t tail95 vbias vss vss nch W=4u L=1u
M96a x96 inp96 tail96 vss nch W=2u L=0.5u
M96b out96 inn96 tail96 vss nch W=2u L=0.5u
M96c x96 x96 vdd vdd pch W=4u L=0.5u
M96d out96 x96 vdd vdd pch W=4u L=0.5u
M96t tail96 vbias vss vss nch W=4u L=1u
M97a x97 inp97 tail97 vss nch W=2u L=0.5u
M97b out97 inn97 tail97 vss nch W=2u L=0.5u
M97c x97 x97 vdd vdd pch W=4u L=0.5u
M97d out97 x97 vdd vdd pch W=4u L=0.5u
M97t tail97 vbias vss vss nch W=4u L=1u
M98a x98 inp98 tail98 vss nch W=2u L=0.5u
M98b out98 inn98 tail98 vss nch W=2u L=0.5u
M98c x98 x98 vdd vdd pch W=4u L=0.5u
M98d out98 x98 vdd vdd pch W=4u L=0.5u
M98t tail98 vbias vss vss nch W=4u L=1u
M99a x99 inp99 tail99 vss nch W=2u L=0.5u
M99b out99 inn99 tail99 vss nch W=2u L=0.5u
M99c x99 x99 vdd vdd pch W=4u L=0.5u
M99d out99 x99 vdd vdd pch W=4u L=0.5u
M99t tail99 vbias vss vss nch W=4u L=1u
M100a x100 inp100 tail100 vss nch W=2u L=0.5u
M100b out100 inn100 tail100 vss nch W=2u L=0.5u
M100c x100 x100 vdd vdd pch W=4u L=0.5u
M100d out100 x100 vdd vdd pch W=4u L=0.5u
M100t tail100 vbias vss vss nch W=4u L=1u
M101a x101 inp101 tail101 vss nch W=2u L=0.5u
M101b out101 inn101 tail101 vss nch W=2u L=0.5u
M101c x101 x101 vdd vdd pch W=4u L=0.5u
M101d out101 x101 vdd vdd pch W=4u L=0.5u
M101t tail101 vbias vss vss nch W=4u L=1u
M102a x102 inp102 tail102 vss nch W=2u L=0.5u
M102b out102 inn102 tail102 vss nch W=2u L=0.5u
M102c x102 x102 vdd vdd pch W=4u L=0.5u
M102d out102 x102 vdd vdd pch W=4u L=0.5u
M102t tail102 vbias vss vss nch W=4u L=1u
M103a x103 inp103 tail103 vss nch W=2u L=0.5u
M103b out103 inn103 tail103 vss nch W=2u L=0.5u
M103c x103 x103 vdd vdd pch W=4u L=0.5u
M103d out103 x103 vdd vdd pch W=4u L=0.5u
M103t tail103 vbias vss vss nch W=4u L=1u
M104a x104 inp104 tail104 vss nch W=2u L=0.5u
M104b out104 inn104 tail104 vss nch W=2u L=0.5u
M104c x104 x104 vdd vdd pch W=4u L=0.5u
M104d out104 x104 vdd vdd pch W=4u L=0.5u
M104t tail104 vbias vss vss nch W=4u L=1u
M105a x105 inp105 tail105 vss nch W=2u L=0.5u
M105b out105 inn105 tail105 vss nch W=2u L=0.5u
M105c x105 x105 vdd vdd pch W=4u L=0.5u
M105d out105 x105 vdd vdd pch W=4u L=0.5u
M105t tail105 vbias vss vss nch W=4u L=1u
M106a x106 inp106 tail106 vss nch W=2u L=0.5u
M106b out106 inn106 tail106 vss nch W=2u L=0.5u
M106c x106 x106 vdd vdd pch W=4u L=0.5u
M106d out106 x106 vdd vdd pch W=4u L=0.5u
M106t tail106 vbias vss vss nch W=4u L=1u
M107a x107 inp107 tail107 vss nch W=2u L=0.5u
M107b out107 inn107 tail107 vss nch W=2u L=0.5u
M107c x107 x107 vdd vdd pch W=4u L=0.5u
M107d out107 x107 vdd vdd pch W=4u L=0.5u
M107t tail107 vbias vss vss nch W=4u L=1u
M108a x108 inp108 tail108 vss nch W=2u L=0.5u
M108b out108 inn108 tail108 vss nch W=2u L=0.5u
M108c x108 x108 vdd vdd pch W=4u L=0.5u
M108d out108 x108 vdd vdd pch W=4u L=0.5u
M108t tail108 vbias vss vss nch W=4u L=1u
M109a x109 inp109 tail109 vss nch W=2u L=0.5u
M109b out109 inn109 tail109 vss nch W=2u L=0.5u
M109c x109 x109 vdd vdd pch W=4u L=0.5u
M109d out109 x109 vdd vdd pch W=4u L=0.5u
M109t tail109 vbias vss vss nch W=4u L=1u
M110a x110 inp110 tail110 vss nch W=2u L=0.5u
M110b out110 inn110 tail110 vss nch W=2u L=0.5u
M110c x110 x110 vdd vdd pch W=4u L=0.5u
M110d out110 x110 vdd vdd pch W=4u L=0.5u
M110t tail110 vbias vss vss nch W=4u L=1u
M111a x111 inp111 tail111 vss nch W=2u L=0.5u
M111b out111 inn111 tail111 vss nch W=2u L=0.5u
M111c x111 x111 vdd vdd pch W=4u L=0.5u
M111d out111 x111 vdd vdd pch W=4u L=0.5u
M111t tail111 vbias vss vss nch W=4u L=1u
M112a x112 inp112 tail112 vss nch W=2u L=0.5u
M112b out112 inn112 tail112 vss nch W=2u L=0.5u
M112c x112 x112 vdd vdd pch W=4u L=0.5u
M112d out112 x112 vdd vdd pch W=4u L=0.5u
M112t tail112 vbias vss vss nch W=4u L=1u
M113a x113 inp113 tail113 vss nch W=2u L=0.5u
M113b out113 inn113 tail113 vss nch W=2u L=0.5u
M113c x113 x113 vdd vdd pch W=4u L=0.5u
M113d out113 x113 vdd vdd pch W=4u L=0.5u
M113t tail113 vbias vss vss nch W=4u L=1u
M114a x114 inp114 tail114 vss nch W=2u L=0.5u
M114b out114 inn114 tail114 vss nch W=2u L=0.5u
M114c x114 x114 vdd vdd pch W=4u L=0.5u
M114d out114 x114 vdd vdd pch W=4u L=0.5u
M114t tail114 vbias vss vss nch W=4u L=1u
M115a x115 inp115 tail115 vss nch W=2u L=0.5u
M115b out115 inn115 tail115 vss nch W=2u L=0.5u
M115c x115 x115 vdd vdd pch W=4u L=0.5u
M115d out115 x115 vdd vdd pch W=4u L=0.5u
M115t tail115 vbias vss vss nch W=4u L=1u
M116a x116 inp116 tail116 vss nch W=2u L=0.5u
M116b out116 inn116 tail116 vss nch W=2u L=0.5u
M116c x116 x116 vdd vdd pch W=4u L=0.5u
M116d out116 x116 vdd vdd pch W=4u L=0.5u
M116t tail116 vbias vss vss nch W=4u L=1u
M117a x117 inp117 tail117 vss nch W=2u L=0.5u
M117b out117 inn117 tail117 vss nch W=2u L=0.5u
M117c x117 x117 vdd vdd pch W=4u L=0.5u
M117d out117 x117 vdd vdd pch W=4u L=0.5u
M117t tail117 vbias vss vss nch W=4u L=1u
M118a x118 inp118 tail118 vss nch W=2u L=0.5u
M118b out118 inn118 tail118 vss nch W=2u L=0.5u
M118c x118 x118 vdd vdd pch W=4u L=0.5u
M118d out118 x118 vdd vdd pch W=4u L=0.5u
M118t tail118 vbias vss vss nch W=4u L=1u
M119a x119 inp119 tail119 vss nch W=2u L=0.5u
M119b out119 inn119 tail119 vss nch W=2u L=0.5u
M119c x119 x119 vdd vdd pch W=4u L=0.5u
M119d out119 x119 vdd vdd pch W=4u L=0.5u
M119t tail119 vbias vss vss nch W=4u L=1u
M120a x120 inp120 tail120 vss nch W=2u L=0.5u
M120b out120 inn120 tail120 vss nch W=2u L=0.5u
M120c x120 x120 vdd vdd pch W=4u L=0.5u
M120d out120 x120 vdd vdd pch W=4u L=0.5u
M120t tail120 vbias vss vss nch W=4u L=1u
M121a x121 inp121 tail121 vss nch W=2u L=0.5u
M121b out121 inn121 tail121 vss nch W=2u L=0.5u
M121c x121 x121 vdd vdd pch W=4u L=0.5u
M121d out121 x121 vdd vdd pch W=4u L=0.5u
M121t tail121 vbias vss vss nch W=4u L=1u
M122a x122 inp122 tail122 vss nch W=2u L=0.5u
M122b out122 inn122 tail122 vss nch W=2u L=0.5u
M122c x122 x122 vdd vdd pch W=4u L=0.5u
M122d out122 x122 vdd vdd pch W=4u L=0.5u
M122t tail122 vbias vss vss nch W=4u L=1u
M123a x123 inp123 tail123 vss nch W=2u L=0.5u
M123b out123 inn123 tail123 vss nch W=2u L=0.5u
M123c x123 x123 vdd vdd pch W=4u L=0.5u
M123d out123 x123 vdd vdd pch W=4u L=0.5u
M123t tail123 vbias vss vss nch W=4u L=1u
M124a x124 inp124 tail124 vss nch W=2u L=0.5u
M124b out124 inn124 tail124 vss nch W=2u L=0.5u
M124c x124 x124 vdd vdd pch W=4u L=0.5u
M124d out124 x124 vdd vdd pch W=4u L=0.5u
M124t tail124 vbias vss vss nch W=4u L=1u
M125a x125 inp125 tail125 vss nch W=2u L=0.5u
M125b out125 inn125 tail125 vss nch W=2u L=0.5u
M125c x125 x125 vdd vdd pch W=4u L=0.5u
M125d out125 x125 vdd vdd pch W=4u L=0.5u
M125t tail125 vbias vss vss nch W=4u L=1u
M126a x126 inp126 tail126 vss nch W=2u L=0.5u
M126b out126 inn126 tail126 vss nch W=2u L=0.5u
M126c x126 x126 vdd vdd pch W=4u L=0.5u
M126d out126 x126 vdd vdd pch W=4u L=0.5u
M126t tail126 vbias vss vss nch W=4u L=1u
M127a x127 inp127 tail127 vss nch W=2u L=0.5u
M127b out127 inn127 tail127 vss nch W=2u L=0.5u
M127c x127 x127 vdd vdd pch W=4u L=0.5u
M127d out127 x127 vdd vdd pch W=4u L=0.5u
M127t tail127 vbias vss vss nch W=4u L=1u
* @RNL {
*   # @SELECT-INSTANCE(model="nch") => @SET-SYMBOL $NMOS;
*   # @SELECT-INSTANCE(model="pch") => @SET-SYMBOL $PMOS;
*   &vdd @ADD-TO $SUPPLY_NET_SET;
*   &vss @ADD-TO $GROUND_NET_SET;
*   %g0 = {#M0a #M0b #M0c #M0d #M0t} @GROUP;
*   %dp0 = #M0a(in_p) #M0b(in_n) #M0t(tail) @AS $DIFFERENTIAL_PAIR;
*   %cm0 = #M0c(ref) #M0d(out) @AS $CURRENT_MIRROR;
*   %axis0 = (_, _);
*   #M0a(a) #M0b(b) %axis0(axis) @AS $MIRRORED;
*   #M0c(a) #M0d(b) %axis0(axis) @AS $MIRRORED;
*   #M0t {#M0a #M0b} @DISTANCE("bottom-to-top", min=2);
*   {#M0a #M0b} {#M0c #M0d} @DISTANCE("bottom-to-top", min=2);
*   %g1 = {#M1a #M1b #M1c #M1d #M1t} @GROUP;
*   %dp1 = #M1a(in_p) #M1b(in_n) #M1t(tail) @AS $DIFFERENTIAL_PAIR;
*   %cm1 = #M1c(ref) #M1d(out) @AS $CURRENT_MIRROR;
*   %axis1 = (_, _);
*   #M1a(a) #M1b(b) %axis1(axis) @AS $MIRRORED;
*   #M1c(a) #M1d(b) %axis1(axis) @AS $MIRRORED;
*   #M1t {#M1a #M1b} @DISTANCE("bottom-to-top", min=2);
*   {#M1a #M1b} {#M1c #M1d} @DISTANCE("bottom-to-top", min=2);
*   %g2 = {#M2a #M2b #M2c #M2d #M2t} @GROUP;
*   %dp2 = #M2a(in_p) #M2b(in_n) #M2t(tail) @AS $DIFFERENTIAL_PAIR;
*   %cm2 = #M2c(ref) #M2d(out) @AS $CURRENT_MIRROR;
*   %axis2 = (_, _);
*   #M2a(a) #M2b(b) %axis2(axis) @AS $MIRRORED;
*   #M2c(a) #M2d(b) %axis2(axis) @AS $MIRRORED;
*   #M2t {#M2a #M2b} @DISTANCE("bottom-to-top", min=2);
*   {#M2a #M2b} {#M2c #M2d} @DISTANCE("bottom-to-top", min=2);
*   %g3 = {#M3a #M3b #M3c #M3d #M3t} @GROUP;
*   %dp3 = #M3a(in_p) #M3b(in_n) #M3t(tail) @AS $DIFFERENTIAL_PAIR;
*   %cm3 = #M3c(ref) #M3d(out) @AS $CURRENT_MIRROR;
*   %axis3 = (_, _);
*   #M3a(a) #M3b(b) %axis3(axis) @AS $MIRRORED;
*   #M3c(a) #M3d(b) %axis3(axis) @AS $MIRRORED;
*   #M3t {#M3a #M3b} @DISTANCE("bottom-to-top", min=2);
*   {#M3a #M3b} {#M3c #M3d} @DISTANCE("bottom-to-top", min=2);
*   %g4 = {#M4a #M4b #M4c #M4d #M4t} @GROUP;
*   %dp4 = #M4a(in_p) #M4b(in_n) #M4t(tail) @AS $DIFFERENTIAL_PAIR;
*   %cm4 = #M4c(ref) #M4d(out) @AS $CURRENT_MIRROR;
*   %axis4 = (_, _);
*   #M4a(a) #M4b(b) %axis4(axis) @AS $MIRRORED;
*   #M4c(a) #M4d(b) %axis4(axis) @AS $MIRRORED;
*   #M4t {#M4a #M4b} @DISTANCE("bottom-to-top", min=2);
*   {#M4a #M4b} {#M4c #M4d} @DISTANCE("bottom-to-top", min=2);
*   %g5 = {#M5a #M5b #M5c #M5d #M5t} @GROUP;
*   %dp5 = #M5a(in_p) #M5b(in_n) #M5t(tail) @AS $DIFFERENTIAL_PAIR;
*   %cm5 = #M5c(ref) #M5d(out) @AS $CURRENT_MIRROR;
*   %axis5 = (_, _);
*   #M5a(a) #M5b(b) %axis5(axis) @AS $MIRRORED;
*   #M5c(a) #M5d(b) %axis5(axis) @AS $MIRRORED;
*   #M5t {#M5a #M5b} @DISTANCE("bottom-to-top", min=2);
*   {#M5a #M5b} {#M5c #M5d} @DISTANCE("bottom-to-top", min=2);
*   %g6 = {#M6a #M6b #M6c #M6d #M6t} @GROUP;
*   %dp6 = #M6a(in_p) #M6b(in_n) #M6t(tail) @AS $DIFFERENTIAL_PAIR;
*   %cm6 = #M6c(ref) #M6d(out) @AS $CURRENT_MIRROR;
*   %axis6 = (_, _);
*   #M6a(a) #M6b(b) %axis6(axis) @AS $MIRRORED;
*   #M6c(a) #M6d(b) %axis6(axis) @AS $MIRRORED;
*   #M6t {#M6a #M6b} @DISTANCE("bottom-to-top", min=2);
*   {#M6a #M6b} {#M6c #M6d} @DISTANCE("bottom-to-top", min=2);
*   %g7 = {#M7a #M7b #M7c #M7d #M7t} @GROUP;
*   %dp7 = #M7a(in_p) #M7b(in_n) #M7t(tail) @AS $DIFFERENTIAL_PAIR;
*   %cm7 = #M7c(ref) #M7d(out) @AS $CURRENT_MIRROR;
*   %axis7 = (_, _);
*   #M7a(a) #M7b(b) %axis7(axis) @AS $MIRRORED;
*   #M7c(a) #M7d(b) %axis7(axis) @AS $MIRRORED;
*   #M7t {#M7a #M7b} @DISTANCE("bottom-to-top", min=2);
*   {#M7a #M7b} {#M7c #M7d} @DISTANCE("bottom-to-top", min=2);
*   %g8 = {#M8a #M8b #M8c #M8d #M8t} @GROUP;
*   %dp8 = #M8a(in_p) #M8b(in_n) #M8t(tail) @AS $DIFFERENTIAL_PAIR;
*   %cm8 = #M8c(ref) #M8d(out) @AS $CURRENT_MIRROR;
*   %axis8 = (_, _);
*   #M8a(a) #M8b(b) %axis8(axis) @AS $MIRRORED;
*   #M8c(a) #M8d(b) %axis8(axis) @AS $MIRRORED;
*   #M8t {#M8a #M8b} @DISTANCE("bottom-to-top", min=2);
*   {#M8a #M8b} {#M8c #M8d} @DISTANCE("bottom-to-top", min=2);
*   %g9 = {#M9a #M9b #M9c #M9d #M9t} @GROUP;
*   %dp9 = #M9a(in_p) #M9b(in_n) #M9t(tail) @AS $DIFFERENTIAL_PAIR;
*   %cm9 = #M9c(ref) #M9d(out) @AS $CURRENT_MIRROR;
*   %axis9 = (_, _);
*   #M9a(a) #M9b(b) %axis9(axis) @AS $MIRRORED;
*   #M9c(a) #M9d(b) %axis9(axis) @AS $MIRRORED;
*   #M9t {#M9a #M9b} @DISTANCE("bottom-to-top", min=2);
*   {#M9a #M9b} {#M9c #M9d} @DISTANCE("bottom-to-top", min=2);
*   %g10 = {#M10a #M10b #M10c #M10d #M10t} @GROUP;
*   %dp10 = #M10a(in_p) #M10b(in_n) #M10t(tail) @AS $DIFFERENTIAL_PAIR;
*   %cm10 = #M10c(ref) #M10d(out) @AS $CURRENT_MIRROR;
*   %axis10 = (_, _);
*   #M10a(a) #M10b(b) %axis10(axis) @AS $MIRRORED;
*   #M10c(a) #M10d(b) %axis10(axis) @AS $MIRRORED;
*   #M10t {#M10a #M10b} @DISTANCE("bottom-to-top", min=2);
*   {#M10a #M10b} {#M10c #M10d} @DISTANCE("bottom-to-top", min=2);
*   %g11 = {#M11a #M11b #M11c #M11d #M11t} @GROUP;
*   %dp11 = #M11a(in_p) #M11b(in_n) #M11t(tail) @AS $DIFFERENTIAL_PAIR;
*   %cm11 = #M11c(ref) #M11d(out) @AS $CURRENT_MIRROR;
*   %axis11 = (_, _);
*   #M11a(a) #M11b(b) %axis11(axis) @AS $MIRRORED;
*   #M11c(a) #M11d(b) %axis11(axis) @AS $MIRRORED;
*   #M11t {#M11a #M11b} @DISTANCE("bottom-to-top", min=2);
*   {#M11a #M11b} {#M11c #M11d} @DISTANCE("bottom-to-top", min=2);
*   %g12 = {#M12a #M12b #M12c #M12d #M12t} @GROUP;
*   %dp12 = #M12a(in_p) #M12b(in_n) #M12t(tail) @AS $DIFFERENTIAL_PAIR;
*   %cm12 = #M12c(ref) #M12d(out) @AS $CURRENT_MIRROR;
*   %axis12 = (_, _);
*   #M12a(a) #M12b(b) %axis12(axis) @AS $MIRRORED;
*   #M12c(a) #M12d(b) %axis12(axis) @AS $MIRRORED;
*   #M12t {#M12a #M12b} @DISTANCE("bottom-to-top", min=2);
*   {#M12a #M12b} {#M12c #M12d} @DISTANCE("bottom-to-top", min=2);
*   %g13 = {#M13a #M13b #M13c #M13d #M13t} @GROUP;
*   %dp13 = #M13a(in_p) #M13b(in_n) #M13t(tail) @AS $DIFFERENTIAL_PAIR;
*   %cm13 = #M13c(ref) #M13d(out) @AS $CURRENT_MIRROR;
*   %axis13 = (_, _);
*   #M13a(a) #M13b(b) %axis13(axis) @AS $MIRRORED;
*   #M13c(a) #M13d(b) %axis13(axis) @AS $MIRRORED;
*   #M13t {#M13a #M13b} @DISTANCE("bottom-to-top", min=2);
*   {#M13a #M13b} {#M13c #M13d} @DISTANCE("bottom-to-top", min=2);
*   %g14 = {#M14a #M14b #M14c #M14d #M14t} @GROUP;
*   %dp14 = #M14a(in_p) #M14b(in_n) #M14t(tail) @AS $DIFFERENTIAL_PAIR;
*   %cm14 = #M14c(ref) #M14d(out) @AS $CURRENT_MIRROR;
*   %axis14 = (_, _);
*   #M14a(a) #M14b(b) %axis14(axis) @AS $MIRRORED;
*   #M14c(a) #M14d(b) %axis14(axis) @AS $MIRRORED;
*   #M14t {#M14a #M14b} @DISTANCE("bottom-to-top", min=2);
*   {#M14a #M14b} {#M14c #M14d} @DISTANCE("bottom-to-top", min=2);
*   %g15 = {#M15a #M15b #M15c #M15d #M15t} @GROUP;
*   %dp15 = #M15a(in_p) #M15b(in_n) #M15t(tail) @AS $DIFFERENTIAL_PAIR;
*   %cm15 = #M15c(ref) #M15d(out) @AS $CURRENT_MIRROR;
*   %axis15 = (_, _);
*   #M15a(a) #M15b(b) %axis15(axis) @AS $MIRRORED;
*   #M15c(a) #M15d(b) %axis15(axis) @AS $MIRRORED;
*   #M15t {#M15a #M15b} @DISTANCE("bottom-to-top", min=2);
*   {#M15a #M15b} {#M15c #M15d} @DISTANCE("bottom-to-top", min=2);
*   %g16 = {#M16a #M16b #M16c #M16d #M16t} @GROUP;
*   %dp16 = #M16a(in_p) #M16b(in_n) #M16t(tail) @AS $DIFFERENTIAL_PAIR;
*   %cm16 = #M16c(ref) #M16d(out) @AS $CURRENT_MIRROR;
*   %axis16 = (_, _);
*   #M16a(a) #M16b(b) %axis16(axis) @AS $MIRRORED;
*   #M16c(a) #M16d(b) %axis16(axis) @AS $MIRRORED;
*   #M16t {#M16a #M16b} @DISTANCE("bottom-to-top", min=2);
*   {#M16a #M16b} {#M16c #M16d} @DISTANCE("bottom-to-top", min=2);
*   %g17 = {#M17a #M17b #M17c #M17d #M17t} @GROUP;
*   %dp17 = #M17a(in_p) #M17b(in_n) #M17t(tail) @AS $DIFFERENTIAL_PAIR;
*   %cm17 = #M17c(ref) #M17d(out) @AS $CURRENT_MIRROR;
*   %axis17 = (_, _);
*   #M17a(a) #M17b(b) %axis17(axis) @AS $MIRRORED;
*   #M17c(a) #M17d(b) %axis17(axis) @AS $MIRRORED;
*   #M17t {#M17a #M17b} @DISTANCE("bottom-to-top", min=2);
*   {#M17a #M17b} {#M17c #M17d} @DISTANCE("bottom-to-top", min=2);
*   %g18 = {#M18a #M18b #M18c #M18d #M18t} @GROUP;
*   %dp18 = #M18a(in_p) #M18b(in_n) #M18t(tail) @AS $DIFFERENTIAL_PAIR;
*   %cm18 = #M18c(ref) #M18d(out) @AS $CURRENT_MIRROR;
*   %axis18 = (_, _);
*   #M18a(a) #M18b(b) %axis18(axis) @AS $MIRRORED;
*   #M18c(a) #M18d(b) %axis18(axis) @AS $MIRRORED;
*   #M18t {#M18a #M18b} @DISTANCE("bottom-to-top", min=2);
*   {#M18a #M18b} {#M18c #M18d} @DISTANCE("bottom-to-top", min=2);
*   %g19 = {#M19a #M19b #M19c #M19d #M19t} @GROUP;
*   %dp19 = #M19a(in_p) #M19b(in_n) #M19t(tail) @AS $DIFFERENTIAL_PAIR;
*   %cm19 = #M19c(ref) #M19d(out) @AS $CURRENT_MIRROR;
*   %axis19 = (_, _);
*   #M19a(a) #M19b(b) %axis19(axis) @AS $MIRRORED;
*   #M19c(a) #M19d(b) %axis19(axis) @AS $MIRRORED;
*   #M19t {#M19a #M19b} @DISTANCE("bottom-to-top", min=2);
*   {#M19a #M19b} {#M19c #M19d} @DISTANCE("bottom-to-top", min=2);
*   %g20 = {#M20a #M20b #M20c #M20d #M20t} @GROUP;
*   %dp20 = #M20a(in_p) #M20b(in_n) #M20t(tail) @AS $DIFFERENTIAL_PAIR;
*   %cm20 = #M20c(ref) #M20d(out) @AS $CURRENT_MIRROR;
*   %axis20 = (_, _);
*   #M20a(a) #M20b(b) %axis20(axis) @AS $MIRRORED;
*   #M20c(a) #M20d(b) %axis20(axis) @AS $MIRRORED;
*   #M20t {#M20a #M20b} @DISTANCE("bottom-to-top", min=2);
*   {#M20a #M20b} {#M20c #M20d} @DISTANCE("bottom-to-top", min=2);
*   %g21 = {#M21a #M21b #M21c #M21d #M21t} @GROUP;
*   %dp21 = #M21a(in_p) #M21b(in_n) #M21t(tail) @AS $DIFFERENTIAL_PAIR;
*   %cm21 = #M21c(ref) #M21d(out) @AS $CURRENT_MIRROR;
*   %axis21 = (_, _);
*   #M21a(a) #M21b(b) %axis21(axis) @AS $MIRRORED;
*   #M21c(a) #M21d(b) %axis21(axis) @AS $MIRRORED;
*   #M21t {#M21a #M21b} @DISTANCE("bottom-to-top", min=2);
*   {#M21a #M21b} {#M21c #M21d} @DISTANCE("bottom-to-top", min=2);
*   %g22 = {#M22a #M22b #M22c #M22d #M22t} @GROUP;
*   %dp22 = #M22a(in_p) #M22b(in_n) #M22t(tail) @AS $DIFFERENTIAL_PAIR;
*   %cm22 = #M22c(ref) #M22d(out) @AS $CURRENT_MIRROR;
*   %axis22 = (_, _);
*   #M22a(a) #M22b(b) %axis22(axis) @AS $MIRRORED;
*   #M22c(a) #M22d(b) %axis22(axis) @AS $MIRRORED;
*   #M22t {#M22a #M22b} @DISTANCE("bottom-to-top", min=2);
*   {#M22a #M22b} {#M22c #M22d} @DISTANCE("bottom-to-top", min=2);
*   %g23 = {#M23a #M23b #M23c #M23d #M23t} @GROUP;
*   %dp23 = #M23a(in_p) #M23b(in_n) #M23t(tail) @AS $DIFFERENTIAL_PAIR;
*   %cm23 = #M23c(ref) #M23d(out) @AS $CURRENT_MIRROR;
*   %axis23 = (_, _);
*   #M23a(a) #M23b(b) %axis23(axis) @AS $MIRRORED;
*   #M23c(a) #M23d(b) %axis23(axis) @AS $MIRRORED;
*   #M23t {#M23a #M23b} @DISTANCE("bottom-to-top", min=2);
*   {#M23a #M23b} {#M23c #M23d} @DISTANCE("bottom-to-top", min=2);
*   %g24 = {#M24a #M24b #M24c #M24d #M24t} @GROUP;
*   %dp24 = #M24a(in_p) #M24b(in_n) #M24t(tail) @AS $DIFFERENTIAL_PAIR;
*   %cm24 = #M24c(ref) #M24d(out) @AS $CURRENT_MIRROR;
*   %axis24 = (_, _);
*   #M24a(a) #M24b(b) %axis24(axis) @AS $MIRRORED;
*   #M24c(a) #M24d(b) %axis24(axis) @AS $MIRRORED;
*   #M24t {#M24a #M24b} @DISTANCE("bottom-to-top", min=2);
*   {#M24a #M24b} {#M24c #M24d} @DISTANCE("bottom-to-top", min=2);
*   %g25 = {#M25a #M25b #M25c #M25d #M25t} @GROUP;
*   %dp25 = #M25a(in_p) #M25b(in_n) #M25t(tail) @AS $DIFFERENTIAL_PAIR;
*   %cm25 = #M25c(ref) #M25d(out) @AS $CURRENT_MIRROR;
*   %axis25 = (_, _);
*   #M25a(a) #M25b(b) %axis25(axis) @AS $MIRRORED;
*   #M25c(a) #M25d(b) %axis25(axis) @AS $MIRRORED;
*   #M25t {#M25a #M25b} @DISTANCE("bottom-to-top", min=2);
*   {#M25a #M25b} {#M25c #M25d} @DISTANCE("bottom-to-top", min=2);
*   %g26 = {#M26a #M26b #M26c #M26d #M26t} @GROUP;
*   %dp26 = #M26a(in_p) #M26b(in_n) #M26t(tail) @AS $DIFFERENTIAL_PAIR;
*   %cm26 = #M26c(ref) #M26d(out) @AS $CURRENT_MIRROR;
*   %axis26 = (_, _);
*   #M26a(a) #M26b(b) %axis26(axis) @AS $MIRRORED;
*   #M26c(a) #M26d(b) %axis26(axis) @AS $MIRRORED;
*   #M26t {#M26a #M26b} @DISTANCE("bottom-to-top", min=2);
*   {#M26a #M26b} {#M26c #M26d} @DISTANCE("bottom-to-top", min=2);
*   %g27 = {#M27a #M27b #M27c #M27d #M27t} @GROUP;
*   %dp27 = #M27a(in_p) #M27b(in_n) #M27t(tail) @AS $DIFFERENTIAL_PAIR;
*   %cm27 = #M27c(ref) #M27d(out) @AS $CURRENT_MIRROR;
*   %axis27 = (_, _);
*   #M27a(a) #M27b(b) %axis27(axis) @AS $MIRRORED;
*   #M27c(a) #M27d(b) %axis27(axis) @AS $MIRRORED;
*   #M27t {#M27a #M27b} @DISTANCE("bottom-to-top", min=2);
*   {#M27a #M27b} {#M27c #M27d} @DISTANCE("bottom-to-top", min=2);
*   %g28 = {#M28a #M28b #M28c #M28d #M28t} @GROUP;
*   %dp28 = #M28a(in_p) #M28b(in_n) #M28t(tail) @AS $DIFFERENTIAL_PAIR;
*   %cm28 = #M28c(ref) #M28d(out) @AS $CURRENT_MIRROR;
*   %axis28 = (_, _);
*   #M28a(a) #M28b(b) %axis28(axis) @AS $MIRRORED;
*   #M28c(a) #M28d(b) %axis28(axis) @AS $MIRRORED;
*   #M28t {#M28a #M28b} @DISTANCE("bottom-to-top", min=2);
*   {#M28a #M28b} {#M28c #M28d} @DISTANCE("bottom-to-top", min=2);
*   %g29 = {#M29a #M29b #M29c #M29d #M29t} @GROUP;
*   %dp29 = #M29a(in_p) #M29b(in_n) #M29t(tail) @AS $DIFFERENTIAL_PAIR;
*   %cm29 = #M29c(ref) #M29d(out) @AS $CURRENT_MIRROR;
*   %axis29 = (_, _);
*   #M29a(a) #M29b(b) %axis29(axis) @AS $MIRRORED;
*   #M29c(a) #M29d(b) %axis29(axis) @AS $MIRRORED;
*   #M29t {#M29a #M29b} @DISTANCE("bottom-to-top", min=2);
*   {#M29a #M29b} {#M29c #M29d} @DISTANCE("bottom-to-top", min=2);
*   %g30 = {#M30a #M30b #M30c #M30d #M30t} @GROUP;
*   %dp30 = #M30a(in_p) #M30b(in_n) #M30t(tail) @AS $DIFFERENTIAL_PAIR;
*   %cm30 = #M30c(ref) #M30d(out) @AS $CURRENT_MIRROR;
*   %axis30 = (_, _);
*   #M30a(a) #M30b(b) %axis30(axis) @AS $MIRRORED;
*   #M30c(a) #M30d(b) %axis30(axis) @AS $MIRRORED;
*   #M30t {#M30a #M30b} @DISTANCE("bottom-to-top", min=2);
*   {#M30a #M30b} {#M30c #M30d} @DISTANCE("bottom-to-top", min=2);
*   %g31 = {#M31a #M31b #M31c #M31d #M31t} @GROUP;
*   %dp31 = #M31a(in_p) #M31b(in_n) #M31t(tail) @AS $DIFFERENTIAL_PAIR;
*   %cm31 = #M31c(ref) #M31d(out) @AS $CURRENT_MIRROR;
*   %axis31 = (_, _);
*   #M31a(a) #M31b(b) %axis31(axis) @AS $MIRRORED;
*   #M31c(a) #M31d(b) %axis31(axis) @AS $MIRRORED;
*   #M31t {#M31a #M31b} @DISTANCE("bottom-to-top", min=2);
*   {#M31a #M31b} {#M31c #M31d} @DISTANCE("bottom-to-top", min=2);
*   %g32 = {#M32a #M32b #M32c #M32d #M32t} @GROUP;
*   %dp32 = #M32a(in_p) #M32b(in_n) #M32t(tail) @AS $DIFFERENTIAL_PAIR;
*   %cm32 = #M32c(ref) #M32d(out) @AS $CURRENT_MIRROR;
*   %axis32 = (_, _);
*   #M32a(a) #M32b(b) %axis32(axis) @AS $MIRRORED;
*   #M32c(a) #M32d(b) %axis32(axis) @AS $MIRRORED;
*   #M32t {#M32a #M32b} @DISTANCE("bottom-to-top", min=2);
*   {#M32a #M32b} {#M32c #M32d} @DISTANCE("bottom-to-top", min=2);
*   %g33 = {#M33a #M33b #M33c #M33d #M33t} @GROUP;
*   %dp33 = #M33a(in_p) #M33b(in_n) #M33t(tail) @AS $DIFFERENTIAL_PAIR;
*   %cm33 = #M33c(ref) #M33d(out) @AS $CURRENT_MIRROR;
*   %axis33 = (_, _);
*   #M33a(a) #M33b(b) %axis33(axis) @AS $MIRRORED;
*   #M33c(a) #M33d(b) %axis33(axis) @AS $MIRRORED;
*   #M33t {#M33a #M33b} @DISTANCE("bottom-to-top", min=2);
*   {#M33a #M33b} {#M33c #M33d} @DISTANCE("bottom-to-top", min=2);
*   %g34 = {#M34a #M34b #M34c #M34d #M34t} @GROUP;
*   %dp34 = #M34a(in_p) #M34b(in_n) #M34t(tail) @AS $DIFFERENTIAL_PAIR;
*   %cm34 = #M34c(ref) #M34d(out) @AS $CURRENT_MIRROR;
*   %axis34 = (_, _);
*   #M34a(a) #M34b(b) %axis34(axis) @AS $MIRRORED;
*   #M34c(a) #M34d(b) %axis34(axis) @AS $MIRRORED;
*   #M34t {#M34a #M34b} @DISTANCE("bottom-to-top", min=2);
*   {#M34a #M34b} {#M34c #M34d} @DISTANCE("bottom-to-top", min=2);
*   %g35 = {#M35a #M35b #M35c #M35d #M35t} @GROUP;
*   %dp35 = #M35a(in_p) #M35b(in_n) #M35t(tail) @AS $DIFFERENTIAL_PAIR;
*   %cm35 = #M35c(ref) #M35d(out) @AS $CURRENT_MIRROR;
*   %axis35 = (_, _);
*   #M35a(a) #M35b(b) %axis35(axis) @AS $MIRRORED;
*   #M35c(a) #M35d(b) %axis35(axis) @AS $MIRRORED;
*   #M35t {#M35a #M35b} @DISTANCE("bottom-to-top", min=2);
*   {#M35a #M35b} {#M35c #M35d} @DISTANCE("bottom-to-top", min=2);
*   %g36 = {#M36a #M36b #M36c #M36d #M36t} @GROUP;
*   %dp36 = #M36a(in_p) #M36b(in_n) #M36t(tail) @AS $DIFFERENTIAL_PAIR;
*   %cm36 = #M36c(ref) #M36d(out) @AS $CURRENT_MIRROR;
*   %axis36 = (_, _);
*   #M36a(a) #M36b(b) %axis36(axis) @AS $MIRRORED;
*   #M36c(a) #M36d(b) %axis36(axis) @AS $MIRRORED;
*   #M36t {#M36a #M36b} @DISTANCE("bottom-to-top", min=2);
*   {#M36a #M36b} {#M36c #M36d} @DISTANCE("bottom-to-top", min=2);
*   %g37 = {#M37a #M37b #M37c #M37d #M37t} @GROUP;
*   %dp37 = #M37a(in_p) #M37b(in_n) #M37t(tail) @AS $DIFFERENTIAL_PAIR;
*   %cm37 = #M37c(ref) #M37d(out) @AS $CURRENT_MIRROR;
*   %axis37 = (_, _);
*   #M37a(a) #M37b(b) %axis37(axis) @AS $MIRRORED;
*   #M37c(a) #M37d(b) %axis37(axis) @AS $MIRRORED;
*   #M37t {#M37a #M37b} @DISTANCE("bottom-to-top", min=2);
*   {#M37a #M37b} {#M37c #M37d} @DISTANCE("bottom-to-top", min=2);
*   %g38 = {#M38a #M38b #M38c #M38d #M38t} @GROUP;
*   %dp38 = #M38a(in_p) #M38b(in_n) #M38t(tail) @AS $DIFFERENTIAL_PAIR;
*   %cm38 = #M38c(ref) #M38d(out) @AS $CURRENT_MIRROR;
*   %axis38 = (_, _);
*   #M38a(a) #M38b(b) %axis38(axis) @AS $MIRRORED;
*   #M38c(a) #M38d(b) %axis38(axis) @AS $MIRRORED;
*   #M38t {#M38a #M38b} @DISTANCE("bottom-to-top", min=2);
*   {#M38a #M38b} {#M38c #M38d} @DISTANCE("bottom-to-top", min=2);
*   %g39 = {#M39a #M39b #M39c #M39d #M39t} @GROUP;
*   %dp39 = #M39a(in_p) #M39b(in_n) #M39t(tail) @AS $DIFFERENTIAL_PAIR;
*   %cm39 = #M39c(ref) #M39d(out) @AS $CURRENT_MIRROR;
*   %axis39 = (_, _);
*   #M39a(a) #M39b(b) %axis39(axis) @AS $MIRRORED;
*   #M39c(a) #M39d(b) %axis39(axis) @AS $MIRRORED;
*   #M39t {#M39a #M39b} @DISTANCE("bottom-to-top", min=2);
*   {#M39a #M39b} {#M39c #M39d} @DISTANCE("bottom-to-top", min=2);
*   %g40 = {#M40a #M40b #M40c #M40d #M40t} @GROUP;
*   %dp40 = #M40a(in_p) #M40b(in_n) #M40t(tail) @AS $DIFFERENTIAL_PAIR;
*   %cm40 = #M40c(ref) #M40d(out) @AS $CURRENT_MIRROR;
*   %axis40 = (_, _);
*   #M40a(a) #M40b(b) %axis40(axis) @AS $MIRRORED;
*   #M40c(a) #M40d(b) %axis40(axis) @AS $MIRRORED;
*   #M40t {#M40a #M40b} @DISTANCE("bottom-to-top", min=2);
*   {#M40a #M40b} {#M40c #M40d} @DISTANCE("bottom-to-top", min=2);
*   %g41 = {#M41a #M41b #M41c #M41d #M41t} @GROUP;
*   %dp41 = #M41a(in_p) #M41b(in_n) #M41t(tail) @AS $DIFFERENTIAL_PAIR;
*   %cm41 = #M41c(ref) #M41d(out) @AS $CURRENT_MIRROR;
*   %axis41 = (_, _);
*   #M41a(a) #M41b(b) %axis41(axis) @AS $MIRRORED;
*   #M41c(a) #M41d(b) %axis41(axis) @AS $MIRRORED;
*   #M41t {#M41a #M41b} @DISTANCE("bottom-to-top", min=2);
*   {#M41a #M41b} {#M41c #M41d} @DISTANCE("bottom-to-top", min=2);
*   %g42 = {#M42a #M42b #M42c #M42d #M42t} @GROUP;
*   %dp42 = #M42a(in_p) #M42b(in_n) #M42t(tail) @AS $DIFFERENTIAL_PAIR;
*   %cm42 = #M42c(ref) #M42d(out) @AS $CURRENT_MIRROR;
*   %axis42 = (_, _);
*   #M42a(a) #M42b(b) %axis42(axis) @AS $MIRRORED;
*   #M42c(a) #M42d(b) %axis42(axis) @AS $MIRRORED;
*   #M42t {#M42a #M42b} @DISTANCE("bottom-to-top", min=2);
*   {#M42a #M42b} {#M42c #M42d} @DISTANCE("bottom-to-top", min=2);
*   %g43 = {#M43a #M43b #M43c #M43d #M43t} @GROUP;
*   %dp43 = #M43a(in_p) #M43b(in_n) #M43t(tail) @AS $DIFFERENTIAL_PAIR;
*   %cm43 = #M43c(ref) #M43d(out) @AS $CURRENT_MIRROR;
*   %axis43 = (_, _);
*   #M43a(a) #M43b(b) %axis43(axis) @AS $MIRRORED;
*   #M43c(a) #M43d(b) %axis43(axis) @AS $MIRRORED;
*   #M43t {#M43a #M43b} @DISTANCE("bottom-to-top", min=2);
*   {#M43a #M43b} {#M43c #M43d} @DISTANCE("bottom-to-top", min=2);
*   %g44 = {#M44a #M44b #M44c #M44d #M44t} @GROUP;
*   %dp44 = #M44a(in_p) #M44b(in_n) #M44t(tail) @AS $DIFFERENTIAL_PAIR;
*   %cm44 = #M44c(ref) #M44d(out) @AS $CURRENT_MIRROR;
*   %axis44 = (_, _);
*   #M44a(a) #M44b(b) %axis44(axis) @AS $MIRRORED;
*   #M44c(a) #M44d(b) %axis44(axis) @AS $MIRRORED;
*   #M44t {#M44a #M44b} @DISTANCE("bottom-to-top", min=2);
*   {#M44a #M44b} {#M44c #M44d} @DISTANCE("bottom-to-top", min=2);
*   %g45 = {#M45a #M45b #M45c #M45d #M45t} @GROUP;
*   %dp45 = #M45a(in_p) #M45b(in_n) #M45t(tail) @AS $DIFFERENTIAL_PAIR;
*   %cm45 = #M45c(ref) #M45d(out) @AS $CURRENT_MIRROR;
*   %axis45 = (_, _);
*   #M45a(a) #M45b(b) %axis45(axis) @AS $MIRRORED;
*   #M45c(a) #M45d(b) %axis45(axis) @AS $MIRRORED;
*   #M45t {#M45a #M45b} @DISTANCE("bottom-to-top", min=2);
*   {#M45a #M45b} {#M45c #M45d} @DISTANCE("bottom-to-top", min=2);
*   %g46 = {#M46a #M46b #M46c #M46d #M46t} @GROUP;
*   %dp46 = #M46a(in_p) #M46b(in_n) #M46t(tail) @AS $DIFFERENTIAL_PAIR;
*   %cm46 = #M46c(ref) #M46d(out) @AS $CURRENT_MIRROR;
*   %axis46 = (_, _);
*   #M46a(a) #M46b(b) %axis46(axis) @AS $MIRRORED;
*   #M46c(a) #M46d(b) %axis46(axis) @AS $MIRRORED;
*   #M46t {#M46a #M46b} @DISTANCE("bottom-to-top", min=2);
*   {#M46a #M46b} {#M46c #M46d} @DISTANCE("bottom-to-top", min=2);
*   %g47 = {#M47a #M47b #M47c #M47d #M47t} @GROUP;
*   %dp47 = #M47a(in_p) #M47b(in_n) #M47t(tail) @AS $DIFFERENTIAL_PAIR;
*   %cm47 = #M47c(ref) #M47d(out) @AS $CURRENT_MIRROR;
*   %axis47 = (_, _);
*   #M47a(a) #M47b(b) %axis47(axis) @AS $MIRRORED;
*   #M47c(a) #M47d(b) %axis47(axis) @AS $MIRRORED;
*   #M47t {#M47a #M47b} @DISTANCE("bottom-to-top", min=2);
*   {#M47a #M47b} {#M47c #M47d} @DISTANCE("bottom-to-top", min=2);
*   %g48 = {#M48a #M48b #M48c #M48d #M48t} @GROUP;
*   %dp48 = #M48a(in_p) #M48b(in_n) #M48t(tail) @AS $DIFFERENTIAL_PAIR;
*   %cm48 = #M48c(ref) #M48d(out) @AS $CURRENT_MIRROR;
*   %axis48 = (_, _);
*   #M48a(a) #M48b(b) %axis48(axis) @AS $MIRRORED;
*   #M48c(a) #M48d(b) %axis48(axis) @AS $MIRRORED;
*   #M48t {#M48a #M48b} @DISTANCE("bottom-to-top", min=2);
*   {#M48a #M48b} {#M48c #M48d} @DISTANCE("bottom-to-top", min=2);
*   %g49 = {#M49a #M49b #M49c #M49d #M49t} @GROUP;
*   %dp49 = #M49a(in_p) #M49b(in_n) #M49t(tail) @AS $DIFFERENTIAL_PAIR;
*   %cm49 = #M49c(ref) #M49d(out) @AS $CURRENT_MIRROR;
*   %axis49 = (_, _);
*   #M49a(a) #M49b(b) %axis49(axis) @AS $MIRRORED;
*   #M49c(a) #M49d(b) %axis49(axis) @AS $MIRRORED;
*   #M49t {#M49a #M49b} @DISTANCE("bottom-to-top", min=2);
*   {#M49a #M49b} {#M49c #M49d} @DISTANCE("bottom-to-top", min=2);
*   %g50 = {#M50a #M50b #M50c #M50d #M50t} @GROUP;
*   %dp50 = #M50a(in_p) #M50b(in_n) #M50t(tail) @AS $DIFFERENTIAL_PAIR;
*   %cm50 = #M50c(ref) #M50d(out) @AS $CURRENT_MIRROR;
*   %axis50 = (_, _);
*   #M50a(a) #M50b(b) %axis50(axis) @AS $MIRRORED;
*   #M50c(a) #M50d(b) %axis50(axis) @AS $MIRRORED;
*   #M50t {#M50a #M50b} @DISTANCE("bottom-to-top", min=2);
*   {#M50a #M50b} {#M50c #M50d} @DISTANCE("bottom-to-top", min=2);
*   %g51 = {#M51a #M51b #M51c #M51d #M51t} @GROUP;
*   %dp51 = #M51a(in_p) #M51b(in_n) #M51t(tail) @AS $DIFFERENTIAL_PAIR;
*   %cm51 = #M51c(ref) #M51d(out) @AS $CURRENT_MIRROR;
*   %axis51 = (_, _);
*   #M51a(a) #M51b(b) %axis51(axis) @AS $MIRRORED;
*   #M51c(a) #M51d(b) %axis51(axis) @AS $MIRRORED;
*   #M51t {#M51a #M51b} @DISTANCE("bottom-to-top", min=2);
*   {#M51a #M51b} {#M51c #M51d} @DISTANCE("bottom-to-top", min=2);
*   %g52 = {#M52a #M52b #M52c #M52d #M52t} @GROUP;
*   %dp52 = #M52a(in_p) #M52b(in_n) #M52t(tail) @AS $DIFFERENTIAL_PAIR;
*   %cm52 = #M52c(ref) #M52d(out) @AS $CURRENT_MIRROR;
*   %axis52 = (_, _);
*   #M52a(a) #M52b(b) %axis52(axis) @AS $MIRRORED;
*   #M52c(a) #M52d(b) %axis52(axis) @AS $MIRRORED;
*   #M52t {#M52a #M52b} @DISTANCE("bottom-to-top", min=2);
*   {#M52a #M52b} {#M52c #M52d} @DISTANCE("bottom-to-top", min=2);
*   %g53 = {#M53a #M53b #M53c #M53d #M53t} @GROUP;
*   %dp53 = #M53a(in_p) #M53b(in_n) #M53t(tail) @AS $DIFFERENTIAL_PAIR;
*   %cm53 = #M53c(ref) #M53d(out) @AS $CURRENT_MIRROR;
*   %axis53 = (_, _);
*   #M53a(a) #M53b(b) %axis53(axis) @AS $MIRRORED;
*   #M53c(a) #M53d(b) %axis53(axis) @AS $MIRRORED;
*   #M53t {#M53a #M53b} @DISTANCE("bottom-to-top", min=2);
*   {#M53a #M53b} {#M53c #M53d} @DISTANCE("bottom-to-top", min=2);
*   %g54 = {#M54a #M54b #M54c #M54d #M54t} @GROUP;
*   %dp54 = #M54a(in_p) #M54b(in_n) #M54t(tail) @AS $DIFFERENTIAL_PAIR;
*   %cm54 = #M54c(ref) #M54d(out) @AS $CURRENT_MIRROR;
*   %axis54 = (_, _);
*   #M54a(a) #M54b(b) %axis54(axis) @AS $MIRRORED;
*   #M54c(a) #M54d(b) %axis54(axis) @AS $MIRRORED;
*   #M54t {#M54a #M54b} @DISTANCE("bottom-to-top", min=2);
*   {#M54a #M54b} {#M54c #M54d} @DISTANCE("bottom-to-top", min=2);
*   %g55 = {#M55a #M55b #M55c #M55d #M55t} @GROUP;
*   %dp55 = #M55a(in_p) #M55b(in_n) #M55t(tail) @AS $DIFFERENTIAL_PAIR;
*   %cm55 = #M55c(ref) #M55d(out) @AS $CURRENT_MIRROR;
*   %axis55 = (_, _);
*   #M55a(a) #M55b(b) %axis55(axis) @AS $MIRRORED;
*   #M55c(a) #M55d(b) %axis55(axis) @AS $MIRRORED;
*   #M55t {#M55a #M55b} @DISTANCE("bottom-to-top", min=2);
*   {#M55a #M55b} {#M55c #M55d} @DISTANCE("bottom-to-top", min=2);
*   %g56 = {#M56a #M56b #M56c #M56d #M56t} @GROUP;
*   %dp56 = #M56a(in_p) #M56b(in_n) #M56t(tail) @AS $DIFFERENTIAL_PAIR;
*   %cm56 = #M56c(ref) #M56d(out) @AS $CURRENT_MIRROR;
*   %axis56 = (_, _);
*   #M56a(a) #M56b(b) %axis56(axis) @AS $MIRRORED;
*   #M56c(a) #M56d(b) %axis56(axis) @AS $MIRRORED;
*   #M56t {#M56a #M56b} @DISTANCE("bottom-to-top", min=2);
*   {#M56a #M56b} {#M56c #M56d} @DISTANCE("bottom-to-top", min=2);
*   %g57 = {#M57a #M57b #M57c #M57d #M57t} @GROUP;
*   %dp57 = #M57a(in_p) #M57b(in_n) #M57t(tail) @AS $DIFFERENTIAL_PAIR;
*   %cm57 = #M57c(ref) #M57d(out) @AS $CURRENT_MIRROR;
*   %axis57 = (_, _);
*   #M57a(a) #M57b(b) %axis57(axis) @AS $MIRRORED;
*   #M57c(a) #M57d(b) %axis57(axis) @AS $MIRRORED;
*   #M57t {#M57a #M57b} @DISTANCE("bottom-to-top", min=2);
*   {#M57a #M57b} {#M57c #M57d} @DISTANCE("bottom-to-top", min=2);
*   %g58 = {#M58a #M58b #M58c #M58d #M58t} @GROUP;
*   %dp58 = #M58a(in_p) #M58b(in_n) #M58t(tail) @AS $DIFFERENTIAL_PAIR;
*   %cm58 = #M58c(ref) #M58d(out) @AS $CURRENT_MIRROR;
*   %axis58 = (_, _);
*   #M58a(a) #M58b(b) %axis58(axis) @AS $MIRRORED;
*   #M58c(a) #M58d(b) %axis58(axis) @AS $MIRRORED;
*   #M58t {#M58a #M58b} @DISTANCE("bottom-to-top", min=2);
*   {#M58a #M58b} {#M58c #M58d} @DISTANCE("bottom-to-top", min=2);
*   %g59 = {#M59a #M59b #M59c #M59d #M59t} @GROUP;
*   %dp59 = #M59a(in_p) #M59b(in_n) #M59t(tail) @AS $DIFFERENTIAL_PAIR;
*   %cm59 = #M59c(ref) #M59d(out) @AS $CURRENT_MIRROR;
*   %axis59 = (_, _);
*   #M59a(a) #M59b(b) %axis59(axis) @AS $MIRRORED;
*   #M59c(a) #M59d(b) %axis59(axis) @AS $MIRRORED;
*   #M59t {#M59a #M59b} @DISTANCE("bottom-to-top", min=2);
*   {#M59a #M59b} {#M59c #M59d} @DISTANCE("bottom-to-top", min=2);
*   %g60 = {#M60a #M60b #M60c #M60d #M60t} @GROUP;
*   %dp60 = #M60a(in_p) #M60b(in_n) #M60t(tail) @AS $DIFFERENTIAL_PAIR;
*   %cm60 = #M60c(ref) #M60d(out) @AS $CURRENT_MIRROR;
*   %axis60 = (_, _);
*   #M60a(a) #M60b(b) %axis60(axis) @AS $MIRRORED;
*   #M60c(a) #M60d(b) %axis60(axis) @AS $MIRRORED;
*   #M60t {#M60a #M60b} @DISTANCE("bottom-to-top", min=2);
*   {#M60a #M60b} {#M60c #M60d} @DISTANCE("bottom-to-top", min=2);
*   %g61 = {#M61a #M61b #M61c #M61d #M61t} @GROUP;
*   %dp61 = #M61a(in_p) #M61b(in_n) #M61t(tail) @AS $DIFFERENTIAL_PAIR;
*   %cm61 = #M61c(ref) #M61d(out) @AS $CURRENT_MIRROR;
*   %axis61 = (_, _);
*   #M61a(a) #M61b(b) %axis61(axis) @AS $MIRRORED;
*   #M61c(a) #M61d(b) %axis61(axis) @AS $MIRRORED;
*   #M61t {#M61a #M61b} @DISTANCE("bottom-to-top", min=2);
*   {#M61a #M61b} {#M61c #M61d} @DISTANCE("bottom-to-top", min=2);
*   %g62 = {#M62a #M62b #M62c #M62d #M62t} @GROUP;
*   %dp62 = #M62a(in_p) #M62b(in_n) #M62t(tail) @AS $DIFFERENTIAL_PAIR;
*   %cm62 = #M62c(ref) #M62d(out) @AS $CURRENT_MIRROR;
*   %axis62 = (_, _);
*   #M62a(a) #M62b(b) %axis62(axis) @AS $MIRRORED;
*   #M62c(a) #M62d(b) %axis62(axis) @AS $MIRRORED;
*   #M62t {#M62a #M62b} @DISTANCE("bottom-to-top", min=2);
*   {#M62a #M62b} {#M62c #M62d} @DISTANCE("bottom-to-top", min=2);
*   %g63 = {#M63a #M63b #M63c #M63d #M63t} @GROUP;
*   %dp63 = #M63a(in_p) #M63b(in_n) #M63t(tail) @AS $DIFFERENTIAL_PAIR;
*   %cm63 = #M63c(ref) #M63d(out) @AS $CURRENT_MIRROR;
*   %axis63 = (_, _);
*   #M63a(a) #M63b(b) %axis63(axis) @AS $MIRRORED;
*   #M63c(a) #M63d(b) %axis63(axis) @AS $MIRRORED;
*   #M63t {#M63a #M63b} @DISTANCE("bottom-to-top", min=2);
*   {#M63a #M63b} {#M63c #M63d} @DISTANCE("bottom-to-top", min=2);
*   %g64 = {#M64a #M64b #M64c #M64d #M64t} @GROUP;
*   %dp64 = #M64a(in_p) #M64b(in_n) #M64t(tail) @AS $DIFFERENTIAL_PAIR;
*   %cm64 = #M64c(ref) #M64d(out) @AS $CURRENT_MIRROR;
*   %axis64 = (_, _);
*   #M64a(a) #M64b(b) %axis64(axis) @AS $MIRRORED;
*   #M64c(a) #M64d(b) %axis64(axis) @AS $MIRRORED;
*   #M64t {#M64a #M64b} @DISTANCE("bottom-to-top", min=2);
*   {#M64a #M64b} {#M64c #M64d} @DISTANCE("bottom-to-top", min=2);
*   %g65 = {#M65a #M65b #M65c #M65d #M65t} @GROUP;
*   %dp65 = #M65a(in_p) #M65b(in_n) #M65t(tail) @AS $DIFFERENTIAL_PAIR;
*   %cm65 = #M65c(ref) #M65d(out) @AS $CURRENT_MIRROR;
*   %axis65 = (_, _);
*   #M65a(a) #M65b(b) %axis65(axis) @AS $MIRRORED;
*   #M65c(a) #M65d(b) %axis65(axis) @AS $MIRRORED;
*   #M65t {#M65a #M65b} @DISTANCE("bottom-to-top", min=2);
*   {#M65a #M65b} {#M65c #M65d} @DISTANCE("bottom-to-top", min=2);
*   %g66 = {#M66a #M66b #M66c #M66d #M66t} @GROUP;
*   %dp66 = #M66a(in_p) #M66b(in_n) #M66t(tail) @AS $DIFFERENTIAL_PAIR;
*   %cm66 = #M66c(ref) #M66d(out) @AS $CURRENT_MIRROR;
*   %axis66 = (_, _);
*   #M66a(a) #M66b(b) %axis66(axis) @AS $MIRRORED;
*   #M66c(a) #M66d(b) %axis66(axis) @AS $MIRRORED;
*   #M66t {#M66a #M66b} @DISTANCE("bottom-to-top", min=2);
*   {#M66a #M66b} {#M66c #M66d} @DISTANCE("bottom-to-top", min=2);
*   %g67 = {#M67a #M67b #M67c #M67d #M67t} @GROUP;
*   %dp67 = #M67a(in_p) #M67b(in_n) #M67t(tail) @AS $DIFFERENTIAL_PAIR;
*   %cm67 = #M67c(ref) #M67d(out) @AS $CURRENT_MIRROR;
*   %axis67 = (_, _);
*   #M67a(a) #M67b(b) %axis67(axis) @AS $MIRRORED;
*   #M67c(a) #M67d(b) %axis67(axis) @AS $MIRRORED;
*   #M67t {#M67a #M67b} @DISTANCE("bottom-to-top", min=2);
*   {#M67a #M67b} {#M67c #M67d} @DISTANCE("bottom-to-top", min=2);
*   %g68 = {#M68a #M68b #M68c #M68d #M68t} @GROUP;
*   %dp68 = #M68a(in_p) #M68b(in_n) #M68t(tail) @AS $DIFFERENTIAL_PAIR;
*   %cm68 = #M68c(ref) #M68d(out) @AS $CURRENT_MIRROR;
*   %axis68 = (_, _);
*   #M68a(a) #M68b(b) %axis68(axis) @AS $MIRRORED;
*   #M68c(a) #M68d(b) %axis68(axis) @AS $MIRRORED;
*   #M68t {#M68a #M68b} @DISTANCE("bottom-to-top", min=2);
*   {#M68a #M68b} {#M68c #M68d} @DISTANCE("bottom-to-top", min=2);
*   %g69 = {#M69a #M69b #M69c #M69d #M69t} @GROUP;
*   %dp69 = #M69a(in_p) #M69b(in_n) #M69t(tail) @AS $DIFFERENTIAL_PAIR;
*   %cm69 = #M69c(ref) #M69d(out) @AS $CURRENT_MIRROR;
*   %axis69 = (_, _);
*   #M69a(a) #M69b(b) %axis69(axis) @AS $MIRRORED;
*   #M69c(a) #M69d(b) %axis69(axis) @AS $MIRRORED;
*   #M69t {#M69a #M69b} @DISTANCE("bottom-to-top", min=2);
*   {#M69a #M69b} {#M69c #M69d} @DISTANCE("bottom-to-top", min=2);
*   %g70 = {#M70a #M70b #M70c #M70d #M70t} @GROUP;
*   %dp70 = #M70a(in_p) #M70b(in_n) #M70t(tail) @AS $DIFFERENTIAL_PAIR;
*   %cm70 = #M70c(ref) #M70d(out) @AS $CURRENT_MIRROR;
*   %axis70 = (_, _);
*   #M70a(a) #M70b(b) %axis70(axis) @AS $MIRRORED;
*   #M70c(a) #M70d(b) %axis70(axis) @AS $MIRRORED;
*   #M70t {#M70a #M70b} @DISTANCE("bottom-to-top", min=2);
*   {#M70a #M70b} {#M70c #M70d} @DISTANCE("bottom-to-top", min=2);
*   %g71 = {#M71a #M71b #M71c #M71d #M71t} @GROUP;
*   %dp71 = #M71a(in_p) #M71b(in_n) #M71t(tail) @AS $DIFFERENTIAL_PAIR;
*   %cm71 = #M71c(ref) #M71d(out) @AS $CURRENT_MIRROR;
*   %axis71 = (_, _);
*   #M71a(a) #M71b(b) %axis71(axis) @AS $MIRRORED;
*   #M71c(a) #M71d(b) %axis71(axis) @AS $MIRRORED;
*   #M71t {#M71a #M71b} @DISTANCE("bottom-to-top", min=2);
*   {#M71a #M71b} {#M71c #M71d} @DISTANCE("bottom-to-top", min=2);
*   %g72 = {#M72a #M72b #M72c #M72d #M72t} @GROUP;
*   %dp72 = #M72a(in_p) #M72b(in_n) #M72t(tail) @AS $DIFFERENTIAL_PAIR;
*   %cm72 = #M72c(ref) #M72d(out) @AS $CURRENT_MIRROR;
*   %axis72 = (_, _);
*   #M72a(a) #M72b(b) %axis72(axis) @AS $MIRRORED;
*   #M72c(a) #M72d(b) %axis72(axis) @AS $MIRRORED;
*   #M72t {#M72a #M72b} @DISTANCE("bottom-to-top", min=2);
*   {#M72a #M72b} {#M72c #M72d} @DISTANCE("bottom-to-top", min=2);
*   %g73 = {#M73a #M73b #M73c #M73d #M73t} @GROUP;
*   %dp73 = #M73a(in_p) #M73b(in_n) #M73t(tail) @AS $DIFFERENTIAL_PAIR;
*   %cm73 = #M73c(ref) #M73d(out) @AS $CURRENT_MIRROR;
*   %axis73 = (_, _);
*   #M73a(a) #M73b(b) %axis73(axis) @AS $MIRRORED;
*   #M73c(a) #M73d(b) %axis73(axis) @AS $MIRRORED;
*   #M73t {#M73a #M73b} @DISTANCE("bottom-to-top", min=2);
*   {#M73a #M73b} {#M73c #M73d} @DISTANCE("bottom-to-top", min=2);
*   %g74 = {#M74a #M74b #M74c #M74d #M74t} @GROUP;
*   %dp74 = #M74a(in_p) #M74b(in_n) #M74t(tail) @AS $DIFFERENTIAL_PAIR;
*   %cm74 = #M74c(ref) #M74d(out) @AS $CURRENT_MIRROR;
*   %axis74 = (_, _);
*   #M74a(a) #M74b(b) %axis74(axis) @AS $MIRRORED;
*   #M74c(a) #M74d(b) %axis74(axis) @AS $MIRRORED;
*   #M74t {#M74a #M74b} @DISTANCE("bottom-to-top", min=2);
*   {#M74a #M74b} {#M74c #M74d} @DISTANCE("bottom-to-top", min=2);
*   %g75 = {#M75a #M75b #M75c #M75d #M75t} @GROUP;
*   %dp75 = #M75a(in_p) #M75b(in_n) #M75t(tail) @AS $DIFFERENTIAL_PAIR;
*   %cm75 = #M75c(ref) #M75d(out) @AS $CURRENT_MIRROR;
*   %axis75 = (_, _);
*   #M75a(a) #M75b(b) %axis75(axis) @AS $MIRRORED;
*   #M75c(a) #M75d(b) %axis75(axis) @AS $MIRRORED;
*   #M75t {#M75a #M75b} @DISTANCE("bottom-to-top", min=2);
*   {#M75a #M75b} {#M75c #M75d} @DISTANCE("bottom-to-top", min=2);
*   %g76 = {#M76a #M76b #M76c #M76d #M76t} @GROUP;
*   %dp76 = #M76a(in_p) #M76b(in_n) #M76t(tail) @AS $DIFFERENTIAL_PAIR;
*   %cm76 = #M76c(ref) #M76d(out) @AS $CURRENT_MIRROR;
*   %axis76 = (_, _);
*   #M76a(a) #M76b(b) %axis76(axis) @AS $MIRRORED;
*   #M76c(a) #M76d(b) %axis76(axis) @AS $MIRRORED;
*   #M76t {#M76a #M76b} @DISTANCE("bottom-to-top", min=2);
*   {#M76a #M76b} {#M76c #M76d} @DISTANCE("bottom-to-top", min=2);
*   %g77 = {#M77a #M77b #M77c #M77d #M77t} @GROUP;
*   %dp77 = #M77a(in_p) #M77b(in_n) #M77t(tail) @AS $DIFFERENTIAL_PAIR;
*   %cm77 = #M77c(ref) #M77d(out) @AS $CURRENT_MIRROR;
*   %axis77 = (_, _);
*   #M77a(a) #M77b(b) %axis77(axis) @AS $MIRRORED;
*   #M77c(a) #M77d(b) %axis77(axis) @AS $MIRRORED;
*   #M77t {#M77a #M77b} @DISTANCE("bottom-to-top", min=2);
*   {#M77a #M77b} {#M77c #M77d} @DISTANCE("bottom-to-top", min=2);
*   %g78 = {#M78a #M78b #M78c #M78d #M78t} @GROUP;
*   %dp78 = #M78a(in_p) #M78b(in_n) #M78t(tail) @AS $DIFFERENTIAL_PAIR;
*   %cm78 = #M78c(ref) #M78d(out) @AS $CURRENT_MIRROR;
*   %axis78 = (_, _);
*   #M78a(a) #M78b(b) %axis78(axis) @AS $MIRRORED;
*   #M78c(a) #M78d(b) %axis78(axis) @AS $MIRRORED;
*   #M78t {#M78a #M78b} @DISTANCE("bottom-to-top", min=2);
*   {#M78a #M78b} {#M78c #M78d} @DISTANCE("bottom-to-top", min=2);
*   %g79 = {#M79a #M79b #M79c #M79d #M79t} @GROUP;
*   %dp79 = #M79a(in_p) #M79b(in_n) #M79t(tail) @AS $DIFFERENTIAL_PAIR;
*   %cm79 = #M79c(ref) #M79d(out) @AS $CURRENT_MIRROR;
*   %axis79 = (_, _);
*   #M79a(a) #M79b(b) %axis79(axis) @AS $MIRRORED;
*   #M79c(a) #M79d(b) %axis79(axis) @AS $MIRRORED;
*   #M79t {#M79a #M79b} @DISTANCE("bottom-to-top", min=2);
*   {#M79a #M79b} {#M79c #M79d} @DISTANCE("bottom-to-top", min=2);
*   %g80 = {#M80a #M80b #M80c #M80d #M80t} @GROUP;
*   %dp80 = #M80a(in_p) #M80b(in_n) #M80t(tail) @AS $DIFFERENTIAL_PAIR;
*   %cm80 = #M80c(ref) #M80d(out) @AS $CURRENT_MIRROR;
*   %axis80 = (_, _);
*   #M80a(a) #M80b(b) %axis80(axis) @AS $MIRRORED;
*   #M80c(a) #M80d(b) %axis80(axis) @AS $MIRRORED;
*   #M80t {#M80a #M80b} @DISTANCE("bottom-to-top", min=2);
*   {#M80a #M80b} {#M80c #M80d} @DISTANCE("bottom-to-top", min=2);
*   %g81 = {#M81a #M81b #M81c #M81d #M81t} @GROUP;
*   %dp81 = #M81a(in_p) #M81b(in_n) #M81t(tail) @AS $DIFFERENTIAL_PAIR;
*   %cm81 = #M81c(ref) #M81d(out) @AS $CURRENT_MIRROR;
*   %axis81 = (_, _);
*   #M81a(a) #M81b(b) %axis81(axis) @AS $MIRRORED;
*   #M81c(a) #M81d(b) %axis81(axis) @AS $MIRRORED;
*   #M81t {#M81a #M81b} @DISTANCE("bottom-to-top", min=2);
*   {#M81a #M81b} {#M81c #M81d} @DISTANCE("bottom-to-top", min=2);
*   %g82 = {#M82a #M82b #M82c #M82d #M82t} @GROUP;
*   %dp82 = #M82a(in_p) #M82b(in_n) #M82t(tail) @AS $DIFFERENTIAL_PAIR;
*   %cm82 = #M82c(ref) #M82d(out) @AS $CURRENT_MIRROR;
*   %axis82 = (_, _);
*   #M82a(a) #M82b(b) %axis82(axis) @AS $MIRRORED;
*   #M82c(a) #M82d(b) %axis82(axis) @AS $MIRRORED;
*   #M82t {#M82a #M82b} @DISTANCE("bottom-to-top", min=2);
*   {#M82a #M82b} {#M82c #M82d} @DISTANCE("bottom-to-top", min=2);
*   %g83 = {#M83a #M83b #M83c #M83d #M83t} @GROUP;
*   %dp83 = #M83a(in_p) #M83b(in_n) #M83t(tail) @AS $DIFFERENTIAL_PAIR;
*   %cm83 = #M83c(ref) #M83d(out) @AS $CURRENT_MIRROR;
*   %axis83 = (_, _);
*   #M83a(a) #M83b(b) %axis83(axis) @AS $MIRRORED;
*   #M83c(a) #M83d(b) %axis83(axis) @AS $MIRRORED;
*   #M83t {#M83a #M83b} @DISTANCE("bottom-to-top", min=2);
*   {#M83a #M83b} {#M83c #M83d} @DISTANCE("bottom-to-top", min=2);
*   %g84 = {#M84a #M84b #M84c #M84d #M84t} @GROUP;
*   %dp84 = #M84a(in_p) #M84b(in_n) #M84t(tail) @AS $DIFFERENTIAL_PAIR;
*   %cm84 = #M84c(ref) #M84d(out) @AS $CURRENT_MIRROR;
*   %axis84 = (_, _);
*   #M84a(a) #M84b(b) %axis84(axis) @AS $MIRRORED;
*   #M84c(a) #M84d(b) %axis84(axis) @AS $MIRRORED;
*   #M84t {#M84a #M84b} @DISTANCE("bottom-to-top", min=2);
*   {#M84a #M84b} {#M84c #M84d} @DISTANCE("bottom-to-top", min=2);
*   %g85 = {#M85a #M85b #M85c #M85d #M85t} @GROUP;
*   %dp85 = #M85a(in_p) #M85b(in_n) #M85t(tail) @AS $DIFFERENTIAL_PAIR;
*   %cm85 = #M85c(ref) #M85d(out) @AS $CURRENT_MIRROR;
*   %axis85 = (_, _);
*   #M85a(a) #M85b(b) %axis85(axis) @AS $MIRRORED;
*   #M85c(a) #M85d(b) %axis85(axis) @AS $MIRRORED;
*   #M85t {#M85a #M85b} @DISTANCE("bottom-to-top", min=2);
*   {#M85a #M85b} {#M85c #M85d} @DISTANCE("bottom-to-top", min=2);
*   %g86 = {#M86a #M86b #M86c #M86d #M86t} @GROUP;
*   %dp86 = #M86a(in_p) #M86b(in_n) #M86t(tail) @AS $DIFFERENTIAL_PAIR;
*   %cm86 = #M86c(ref) #M86d(out) @AS $CURRENT_MIRROR;
*   %axis86 = (_, _);
*   #M86a(a) #M86b(b) %axis86(axis) @AS $MIRRORED;
*   #M86c(a) #M86d(b) %axis86(axis) @AS $MIRRORED;
*   #M86t {#M86a #M86b} @DISTANCE("bottom-to-top", min=2);
*   {#M86a #M86b} {#M86c #M86d} @DISTANCE("bottom-to-top", min=2);
*   %g87 = {#M87a #M87b #M87c #M87d #M87t} @GROUP;
*   %dp87 = #M87a(in_p) #M87b(in_n) #M87t(tail) @AS $DIFFERENTIAL_PAIR;
*   %cm87 = #M87c(ref) #M87d(out) @AS $CURRENT_MIRROR;
*   %axis87 = (_, _);
*   #M87a(a) #M87b(b) %axis87(axis) @AS $MIRRORED;
*   #M87c(a) #M87d(b) %axis87(axis) @AS $MIRRORED;
*   #M87t {#M87a #M87b} @DISTANCE("bottom-to-top", min=2);
*   {#M87a #M87b} {#M87c #M87d} @DISTANCE("bottom-to-top", min=2);
*   %g88 = {#M88a #M88b #M88c #M88d #M88t} @GROUP;
*   %dp88 = #M88a(in_p) #M88b(in_n) #M88t(tail) @AS $DIFFERENTIAL_PAIR;
*   %cm88 = #M88c(ref) #M88d(out) @AS $CURRENT_MIRROR;
*   %axis88 = (_, _);
*   #M88a(a) #M88b(b) %axis88(axis) @AS $MIRRORED;
*   #M88c(a) #M88d(b) %axis88(axis) @AS $MIRRORED;
*   #M88t {#M88a #M88b} @DISTANCE("bottom-to-top", min=2);
*   {#M88a #M88b} {#M88c #M88d} @DISTANCE("bottom-to-top", min=2);
*   %g89 = {#M89a #M89b #M89c #M89d #M89t} @GROUP;
*   %dp89 = #M89a(in_p) #M89b(in_n) #M89t(tail) @AS $DIFFERENTIAL_PAIR;
*   %cm89 = #M89c(ref) #M89d(out) @AS $CURRENT_MIRROR;
*   %axis89 = (_, _);
*   #M89a(a) #M89b(b) %axis89(axis) @AS $MIRRORED;
*   #M89c(a) #M89d(b) %axis89(axis) @AS $MIRRORED;
*   #M89t {#M89a #M89b} @DISTANCE("bottom-to-top", min=2);
*   {#M89a #M89b} {#M89c #M89d} @DISTANCE("bottom-to-top", min=2);
*   %g90 = {#M90a #M90b #M90c #M90d #M90t} @GROUP;
*   %dp90 = #M90a(in_p) #M90b(in_n) #M90t(tail) @AS $DIFFERENTIAL_PAIR;
*   %cm90 = #M90c(ref) #M90d(out) @AS $CURRENT_MIRROR;
*   %axis90 = (_, _);
*   #M90a(a) #M90b(b) %axis90(axis) @AS $MIRRORED;
*   #M90c(a) #M90d(b) %axis90(axis) @AS $MIRRORED;
*   #M90t {#M90a #M90b} @DISTANCE("bottom-to-top", min=2);
*   {#M90a #M90b} {#M90c #M90d} @DISTANCE("bottom-to-top", min=2);
*   %g91 = {#M91a #M91b #M91c #M91d #M91t} @GROUP;
*   %dp91 = #M91a(in_p) #M91b(in_n) #M91t(tail) @AS $DIFFERENTIAL_PAIR;
*   %cm91 = #M91c(ref) #M91d(out) @AS $CURRENT_MIRROR;
*   %axis91 = (_, _);
*   #M91a(a) #M91b(b) %axis91(axis) @AS $MIRRORED;
*   #M91c(a) #M91d(b) %axis91(axis) @AS $MIRRORED;
*   #M91t {#M91a #M91b} @DISTANCE("bottom-to-top", min=2);
*   {#M91a #M91b} {#M91c #M91d} @DISTANCE("bottom-to-top", min=2);
*   %g92 = {#M92a #M92b #M92c #M92d #M92t} @GROUP;
*   %dp92 = #M92a(in_p) #M92b(in_n) #M92t(tail) @AS $DIFFERENTIAL_PAIR;
*   %cm92 = #M92c(ref) #M92d(out) @AS $CURRENT_MIRROR;
*   %axis92 = (_, _);
*   #M92a(a) #M92b(b) %axis92(axis) @AS $MIRRORED;
*   #M92c(a) #M92d(b) %axis92(axis) @AS $MIRRORED;
*   #M92t {#M92a #M92b} @DISTANCE("bottom-to-top", min=2);
*   {#M92a #M92b} {#M92c #M92d} @DISTANCE("bottom-to-top", min=2);
*   %g93 = {#M93a #M93b #M93c #M93d #M93t} @GROUP;
*   %dp93 = #M93a(in_p) #M93b(in_n) #M93t(tail) @AS $DIFFERENTIAL_PAIR;
*   %cm93 = #M93c(ref) #M93d(out) @AS $CURRENT_MIRROR;
*   %axis93 = (_, _);
*   #M93a(a) #M93b(b) %axis93(axis) @AS $MIRRORED;
*   #M93c(a) #M93d(b) %axis93(axis) @AS $MIRRORED;
*   #M93t {#M93a #M93b} @DISTANCE("bottom-to-top", min=2);
*   {#M93a #M93b} {#M93c #M93d} @DISTANCE("bottom-to-top", min=2);
*   %g94 = {#M94a #M94b #M94c #M94d #M94t} @GROUP;
*   %dp94 = #M94a(in_p) #M94b(in_n) #M94t(tail) @AS $DIFFERENTIAL_PAIR;
*   %cm94 = #M94c(ref) #M94d(out) @AS $CURRENT_MIRROR;
*   %axis94 = (_, _);
*   #M94a(a) #M94b(b) %axis94(axis) @AS $MIRRORED;
*   #M94c(a) #M94d(b) %axis94(axis) @AS $MIRRORED;
*   #M94t {#M94a #M94b} @DISTANCE("bottom-to-top", min=2);
*   {#M94a #M94b} {#M94c #M94d} @DISTANCE("bottom-to-top", min=2);
*   %g95 = {#M95a #M95b #M95c #M95d #M95t} @GROUP;
*   %dp95 = #M95a(in_p) #M95b(in_n) #M95t(tail) @AS $DIFFERENTIAL_PAIR;
*   %cm95 = #M95c(ref) #M95d(out) @AS $CURRENT_MIRROR;
*   %axis95 = (_, _);
*   #M95a(a) #M95b(b) %axis95(axis) @AS $MIRRORED;
*   #M95c(a) #M95d(b) %axis95(axis) @AS $MIRRORED;
*   #M95t {#M95a #M95b} @DISTANCE("bottom-to-top", min=2);
*   {#M95a #M95b} {#M95c #M95d} @DISTANCE("bottom-to-top", min=2);
*   %g96 = {#M96a #M96b #M96c #M96d #M96t} @GROUP;
*   %dp96 = #M96a(in_p) #M96b(in_n) #M96t(tail) @AS $DIFFERENTIAL_PAIR;
*   %cm96 = #M96c(ref) #M96d(out) @AS $CURRENT_MIRROR;
*   %axis96 = (_, _);
*   #M96a(a) #M96b(b) %axis96(axis) @AS $MIRRORED;
*   #M96c(a) #M96d(b) %axis96(axis) @AS $MIRRORED;
*   #M96t {#M96a #M96b} @DISTANCE("bottom-to-top", min=2);
*   {#M96a #M96b} {#M96c #M96d} @DISTANCE("bottom-to-top", min=2);
*   %g97 = {#M97a #M97b #M97c #M97d #M97t} @GROUP;
*   %dp97 = #M97a(in_p) #M97b(in_n) #M97t(tail) @AS $DIFFERENTIAL_PAIR;
*   %cm97 = #M97c(ref) #M97d(out) @AS $CURRENT_MIRROR;
*   %axis97 = (_, _);
*   #M97a(a) #M97b(b) %axis97(axis) @AS $MIRRORED;
*   #M97c(a) #M97d(b) %axis97(axis) @AS $MIRRORED;
*   #M97t {#M97a #M97b} @DISTANCE("bottom-to-top", min=2);
*   {#M97a #M97b} {#M97c #M97d} @DISTANCE("bottom-to-top", min=2);
*   %g98 = {#M98a #M98b #M98c #M98d #M98t} @GROUP;
*   %dp98 = #M98a(in_p) #M98b(in_n) #M98t(tail) @AS $DIFFERENTIAL_PAIR;
*   %cm98 = #M98c(ref) #M98d(out) @AS $CURRENT_MIRROR;
*   %axis98 = (_, _);
*   #M98a(a) #M98b(b) %axis98(axis) @AS $MIRRORED;
*   #M98c(a) #M98d(b) %axis98(axis) @AS $MIRRORED;
*   #M98t {#M98a #M98b} @DISTANCE("bottom-to-top", min=2);
*   {#M98a #M98b} {#M98c #M98d} @DISTANCE("bottom-to-top", min=2);
*   %g99 = {#M99a #M99b #M99c #M99d #M99t} @GROUP;
*   %dp99 = #M99a(in_p) #M99b(in_n) #M99t(tail) @AS $DIFFERENTIAL_PAIR;
*   %cm99 = #M99c(ref) #M99d(out) @AS $CURRENT_MIRROR;
*   %axis99 = (_, _);
*   #M99a(a) #M99b(b) %axis99(axis) @AS $MIRRORED;
*   #M99c(a) #M99d(b) %axis99(axis) @AS $MIRRORED;
*   #M99t {#M99a #M99b} @DISTANCE("bottom-to-top", min=2);
*   {#M99a #M99b} {#M99c #M99d} @DISTANCE("bottom-to-top", min=2);
*   %g100 = {#M100a #M100b #M100c #M100d #M100t} @GROUP;
*   %dp100 = #M100a(in_p) #M100b(in_n) #M100t(tail) @AS $DIFFERENTIAL_PAIR;
*   %cm100 = #M100c(ref) #M100d(out) @AS $CURRENT_MIRROR;
*   %axis100 = (_, _);
*   #M100a(a) #M100b(b) %axis100(axis) @AS $MIRRORED;
*   #M100c(a) #M100d(b) %axis100(axis) @AS $MIRRORED;
*   #M100t {#M100a #M100b} @DISTANCE("bottom-to-top", min=2);
*   {#M100a #M100b} {#M100c #M100d} @DISTANCE("bottom-to-top", min=2);
*   %g101 = {#M101a #M101b #M101c #M101d #M101t} @GROUP;
*   %dp101 = #M101a(in_p) #M101b(in_n) #M101t(tail) @AS $DIFFERENTIAL_PAIR;
*   %cm101 = #M101c(ref) #M101d(out) @AS $CURRENT_MIRROR;
*   %axis101 = (_, _);
*   #M101a(a) #M101b(b) %axis101(axis) @AS $MIRRORED;
*   #M101c(a) #M101d(b) %axis101(axis) @AS $MIRRORED;
*   #M101t {#M101a #M101b} @DISTANCE("bottom-to-top", min=2);
*   {#M101a #M101b} {#M101c #M101d} @DISTANCE("bottom-to-top", min=2);
*   %g102 = {#M102a #M102b #M102c #M102d #M102t} @GROUP;
*   %dp102 = #M102a(in_p) #M102b(in_n) #M102t(tail) @AS $DIFFERENTIAL_PAIR;
*   %cm102 = #M102c(ref) #M102d(out) @AS $CURRENT_MIRROR;
*   %axis102 = (_, _);
*   #M102a(a) #M102b(b) %axis102(axis) @AS $MIRRORED;
*   #M102c(a) #M102d(b) %axis102(axis) @AS $MIRRORED;
*   #M102t {#M102a #M102b} @DISTANCE("bottom-to-top", min=2);
*   {#M102a #M102b} {#M102c #M102d} @DISTANCE("bottom-to-top", min=2);
*   %g103 = {#M103a #M103b #M103c #M103d #M103t} @GROUP;
*   %dp103 = #M103a(in_p) #M103b(in_n) #M103t(tail) @AS $DIFFERENTIAL_PAIR;
*   %cm103 = #M103c(ref) #M103d(out) @AS $CURRENT_MIRROR;
*   %axis103 = (_, _);
*   #M103a(a) #M103b(b) %axis103(axis) @AS $MIRRORED;
*   #M103c(a) #M103d(b) %axis103(axis) @AS $MIRRORED;
*   #M103t {#M103a #M103b} @DISTANCE("bottom-to-top", min=2);
*   {#M103a #M103b} {#M103c #M103d} @DISTANCE("bottom-to-top", min=2);
*   %g104 = {#M104a #M104b #M104c #M104d #M104t} @GROUP;
*   %dp104 = #M104a(in_p) #M104b(in_n) #M104t(tail) @AS $DIFFERENTIAL_PAIR;
*   %cm104 = #M104c(ref) #M104d(out) @AS $CURRENT_MIRROR;
*   %axis104 = (_, _);
*   #M104a(a) #M104b(b) %axis104(axis) @AS $MIRRORED;
*   #M104c(a) #M104d(b) %axis104(axis) @AS $MIRRORED;
*   #M104t {#M104a #M104b} @DISTANCE("bottom-to-top", min=2);
*   {#M104a #M104b} {#M104c #M104d} @DISTANCE("bottom-to-top", min=2);
*   %g105 = {#M105a #M105b #M105c #M105d #M105t} @GROUP;
*   %dp105 = #M105a(in_p) #M105b(in_n) #M105t(tail) @AS $DIFFERENTIAL_PAIR;
*   %cm105 = #M105c(ref) #M105d(out) @AS $CURRENT_MIRROR;
*   %axis105 = (_, _);
*   #M105a(a) #M105b(b) %axis105(axis) @AS $MIRRORED;
*   #M105c(a) #M105d(b) %axis105(axis) @AS $MIRRORED;
*   #M105t {#M105a #M105b} @DISTANCE("bottom-to-top", min=2);
*   {#M105a #M105b} {#M105c #M105d} @DISTANCE("bottom-to-top", min=2);
*   %g106 = {#M106a #M106b #M106c #M106d #M106t} @GROUP;
*   %dp106 = #M106a(in_p) #M106b(in_n) #M106t(tail) @AS $DIFFERENTIAL_PAIR;
*   %cm106 = #M106c(ref) #M106d(out) @AS $CURRENT_MIRROR;
*   %axis106 = (_, _);
*   #M106a(a) #M106b(b) %axis106(axis) @AS $MIRRORED;
*   #M106c(a) #M106d(b) %axis106(axis) @AS $MIRRORED;
*   #M106t {#M106a #M106b} @DISTANCE("bottom-to-top", min=2);
*   {#M106a #M106b} {#M106c #M106d} @DISTANCE("bottom-to-top", min=2);
*   %g107 = {#M107a #M107b #M107c #M107d #M107t} @GROUP;
*   %dp107 = #M107a(in_p) #M107b(in_n) #M107t(tail) @AS $DIFFERENTIAL_PAIR;
*   %cm107 = #M107c(ref) #M107d(out) @AS $CURRENT_MIRROR;
*   %axis107 = (_, _);
*   #M107a(a) #M107b(b) %axis107(axis) @AS $MIRRORED;
*   #M107c(a) #M107d(b) %axis107(axis) @AS $MIRRORED;
*   #M107t {#M107a #M107b} @DISTANCE("bottom-to-top", min=2);
*   {#M107a #M107b} {#M107c #M107d} @DISTANCE("bottom-to-top", min=2);
*   %g108 = {#M108a #M108b #M108c #M108d #M108t} @GROUP;
*   %dp108 = #M108a(in_p) #M108b(in_n) #M108t(tail) @AS $DIFFERENTIAL_PAIR;
*   %cm108 = #M108c(ref) #M108d(out) @AS $CURRENT_MIRROR;
*   %axis108 = (_, _);
*   #M108a(a) #M108b(b) %axis108(axis) @AS $MIRRORED;
*   #M108c(a) #M108d(b) %axis108(axis) @AS $MIRRORED;
*   #M108t {#M108a #M108b} @DISTANCE("bottom-to-top", min=2);
*   {#M108a #M108b} {#M108c #M108d} @DISTANCE("bottom-to-top", min=2);
*   %g109 = {#M109a #M109b #M109c #M109d #M109t} @GROUP;
*   %dp109 = #M109a(in_p) #M109b(in_n) #M109t(tail) @AS $DIFFERENTIAL_PAIR;
*   %cm109 = #M109c(ref) #M109d(out) @AS $CURRENT_MIRROR;
*   %axis109 = (_, _);
*   #M109a(a) #M109b(b) %axis109(axis) @AS $MIRRORED;
*   #M109c(a) #M109d(b) %axis109(axis) @AS $MIRRORED;
*   #M109t {#M109a #M109b} @DISTANCE("bottom-to-top", min=2);
*   {#M109a #M109b} {#M109c #M109d} @DISTANCE("bottom-to-top", min=2);
*   %g110 = {#M110a #M110b #M110c #M110d #M110t} @GROUP;
*   %dp110 = #M110a(in_p) #M110b(in_n) #M110t(tail) @AS $DIFFERENTIAL_PAIR;
*   %cm110 = #M110c(ref) #M110d(out) @AS $CURRENT_MIRROR;
*   %axis110 = (_, _);
*   #M110a(a) #M110b(b) %axis110(axis) @AS $MIRRORED;
*   #M110c(a) #M110d(b) %axis110(axis) @AS $MIRRORED;
*   #M110t {#M110a #M110b} @DISTANCE("bottom-to-top", min=2);
*   {#M110a #M110b} {#M110c #M110d} @DISTANCE("bottom-to-top", min=2);
*   %g111 = {#M111a #M111b #M111c #M111d #M111t} @GROUP;
*   %dp111 = #M111a(in_p) #M111b(in_n) #M111t(tail) @AS $DIFFERENTIAL_PAIR;
*   %cm111 = #M111c(ref) #M111d(out) @AS $CURRENT_MIRROR;
*   %axis111 = (_, _);
*   #M111a(a) #M111b(b) %axis111(axis) @AS $MIRRORED;
*   #M111c(a) #M111d(b) %axis111(axis) @AS $MIRRORED;
*   #M111t {#M111a #M111b} @DISTANCE("bottom-to-top", min=2);
*   {#M111a #M111b} {#M111c #M111d} @DISTANCE("bottom-to-top", min=2);
*   %g112 = {#M112a #M112b #M112c #M112d #M112t} @GROUP;
*   %dp112 = #M112a(in_p) #M112b(in_n) #M112t(tail) @AS $DIFFERENTIAL_PAIR;
*   %cm112 = #M112c(ref) #M112d(out) @AS $CURRENT_MIRROR;
*   %axis112 = (_, _);
*   #M112a(a) #M112b(b) %axis112(axis) @AS $MIRRORED;
*   #M112c(a) #M112d(b) %axis112(axis) @AS $MIRRORED;
*   #M112t {#M112a #M112b} @DISTANCE("bottom-to-top", min=2);
*   {#M112a #M112b} {#M112c #M112d} @DISTANCE("bottom-to-top", min=2);
*   %g113 = {#M113a #M113b #M113c #M113d #M113t} @GROUP;
*   %dp113 = #M113a(in_p) #M113b(in_n) #M113t(tail) @AS $DIFFERENTIAL_PAIR;
*   %cm113 = #M113c(ref) #M113d(out) @AS $CURRENT_MIRROR;
*   %axis113 = (_, _);
*   #M113a(a) #M113b(b) %axis113(axis) @AS $MIRRORED;
*   #M113c(a) #M113d(b) %axis113(axis) @AS $MIRRORED;
*   #M113t {#M113a #M113b} @DISTANCE("bottom-to-top", min=2);
*   {#M113a #M113b} {#M113c #M113d} @DISTANCE("bottom-to-top", min=2);
*   %g114 = {#M114a #M114b #M114c #M114d #M114t} @GROUP;
*   %dp114 = #M114a(in_p) #M114b(in_n) #M114t(tail) @AS $DIFFERENTIAL_PAIR;
*   %cm114 = #M114c(ref) #M114d(out) @AS $CURRENT_MIRROR;
*   %axis114 = (_, _);
*   #M114a(a) #M114b(b) %axis114(axis) @AS $MIRRORED;
*   #M114c(a) #M114d(b) %axis114(axis) @AS $MIRRORED;
*   #M114t {#M114a #M114b} @DISTANCE("bottom-to-top", min=2);
*   {#M114a #M114b} {#M114c #M114d} @DISTANCE("bottom-to-top", min=2);
*   %g115 = {#M115a #M115b #M115c #M115d #M115t} @GROUP;
*   %dp115 = #M115a(in_p) #M115b(in_n) #M115t(tail) @AS $DIFFERENTIAL_PAIR;
*   %cm115 = #M115c(ref) #M115d(out) @AS $CURRENT_MIRROR;
*   %axis115 = (_, _);
*   #M115a(a) #M115b(b) %axis115(axis) @AS $MIRRORED;
*   #M115c(a) #M115d(b) %axis115(axis) @AS $MIRRORED;
*   #M115t {#M115a #M115b} @DISTANCE("bottom-to-top", min=2);
*   {#M115a #M115b} {#M115c #M115d} @DISTANCE("bottom-to-top", min=2);
*   %g116 = {#M116a #M116b #M116c #M116d #M116t} @GROUP;
*   %dp116 = #M116a(in_p) #M116b(in_n) #M116t(tail) @AS $DIFFERENTIAL_PAIR;
*   %cm116 = #M116c(ref) #M116d(out) @AS $CURRENT_MIRROR;
*   %axis116 = (_, _);
*   #M116a(a) #M116b(b) %axis116(axis) @AS $MIRRORED;
*   #M116c(a) #M116d(b) %axis116(axis) @AS $MIRRORED;
*   #M116t {#M116a #M116b} @DISTANCE("bottom-to-top", min=2);
*   {#M116a #M116b} {#M116c #M116d} @DISTANCE("bottom-to-top", min=2);
*   %g117 = {#M117a #M117b #M117c #M117d #M117t} @GROUP;
*   %dp117 = #M117a(in_p) #M117b(in_n) #M117t(tail) @AS $DIFFERENTIAL_PAIR;
*   %cm117 = #M117c(ref) #M117d(out) @AS $CURRENT_MIRROR;
*   %axis117 = (_, _);
*   #M117a(a) #M117b(b) %axis117(axis) @AS $MIRRORED;
*   #M117c(a) #M117d(b) %axis117(axis) @AS $MIRRORED;
*   #M117t {#M117a #M117b} @DISTANCE("bottom-to-top", min=2);
*   {#M117a #M117b} {#M117c #M117d} @DISTANCE("bottom-to-top", min=2);
*   %g118 = {#M118a #M118b #M118c #M118d #M118t} @GROUP;
*   %dp118 = #M118a(in_p) #M118b(in_n) #M118t(tail) @AS $DIFFERENTIAL_PAIR;
*   %cm118 = #M118c(ref) #M118d(out) @AS $CURRENT_MIRROR;
*   %axis118 = (_, _);
*   #M118a(a) #M118b(b) %axis118(axis) @AS $MIRRORED;
*   #M118c(a) #M118d(b) %axis118(axis) @AS $MIRRORED;
*   #M118t {#M118a #M118b} @DISTANCE("bottom-to-top", min=2);
*   {#M118a #M118b} {#M118c #M118d} @DISTANCE("bottom-to-top", min=2);
*   %g119 = {#M119a #M119b #M119c #M119d #M119t} @GROUP;
*   %dp119 = #M119a(in_p) #M119b(in_n) #M119t(tail) @AS $DIFFERENTIAL_PAIR;
*   %cm119 = #M119c(ref) #M119d(out) @AS $CURRENT_MIRROR;
*   %axis119 = (_, _);
*   #M119a(a) #M119b(b) %axis119(axis) @AS $MIRRORED;
*   #M119c(a) #M119d(b) %axis119(axis) @AS $MIRRORED;
*   #M119t {#M119a #M119b} @DISTANCE("bottom-to-top", min=2);
*   {#M119a #M119b} {#M119c #M119d} @DISTANCE("bottom-to-top", min=2);
*   %g120 = {#M120a #M120b #M120c #M120d #M120t} @GROUP;
*   %dp120 = #M120a(in_p) #M120b(in_n) #M120t(tail) @AS $DIFFERENTIAL_PAIR;
*   %cm120 = #M120c(ref) #M120d(out) @AS $CURRENT_MIRROR;
*   %axis120 = (_, _);
*   #M120a(a) #M120b(b) %axis120(axis) @AS $MIRRORED;
*   #M120c(a) #M120d(b) %axis120(axis) @AS $MIRRORED;
*   #M120t {#M120a #M120b} @DISTANCE("bottom-to-top", min=2);
*   {#M120a #M120b} {#M120c #M120d} @DISTANCE("bottom-to-top", min=2);
*   %g121 = {#M121a #M121b #M121c #M121d #M121t} @GROUP;
*   %dp121 = #M121a(in_p) #M121b(in_n) #M121t(tail) @AS $DIFFERENTIAL_PAIR;
*   %cm121 = #M121c(ref) #M121d(out) @AS $CURRENT_MIRROR;
*   %axis121 = (_, _);
*   #M121a(a) #M121b(b) %axis121(axis) @AS $MIRRORED;
*   #M121c(a) #M121d(b) %axis121(axis) @AS $MIRRORED;
*   #M121t {#M121a #M121b} @DISTANCE("bottom-to-top", min=2);
*   {#M121a #M121b} {#M121c #M121d} @DISTANCE("bottom-to-top", min=2);
*   %g122 = {#M122a #M122b #M122c #M122d #M122t} @GROUP;
*   %dp122 = #M122a(in_p) #M122b(in_n) #M122t(tail) @AS $DIFFERENTIAL_PAIR;
*   %cm122 = #M122c(ref) #M122d(out) @AS $CURRENT_MIRROR;
*   %axis122 = (_, _);
*   #M122a(a) #M122b(b) %axis122(axis) @AS $MIRRORED;
*   #M122c(a) #M122d(b) %axis122(axis) @AS $MIRRORED;
*   #M122t {#M122a #M122b} @DISTANCE("bottom-to-top", min=2);
*   {#M122a #M122b} {#M122c #M122d} @DISTANCE("bottom-to-top", min=2);
*   %g123 = {#M123a #M123b #M123c #M123d #M123t} @GROUP;
*   %dp123 = #M123a(in_p) #M123b(in_n) #M123t(tail) @AS $DIFFERENTIAL_PAIR;
*   %cm123 = #M123c(ref) #M123d(out) @AS $CURRENT_MIRROR;
*   %axis123 = (_, _);
*   #M123a(a) #M123b(b) %axis123(axis) @AS $MIRRORED;
*   #M123c(a) #M123d(b) %axis123(axis) @AS $MIRRORED;
*   #M123t {#M123a #M123b} @DISTANCE("bottom-to-top", min=2);
*   {#M123a #M123b} {#M123c #M123d} @DISTANCE("bottom-to-top", min=2);
*   %g124 = {#M124a #M124b #M124c #M124d #M124t} @GROUP;
*   %dp124 = #M124a(in_p) #M124b(in_n) #M124t(tail) @AS $DIFFERENTIAL_PAIR;
*   %cm124 = #M124c(ref) #M124d(out) @AS $CURRENT_MIRROR;
*   %axis124 = (_, _);
*   #M124a(a) #M124b(b) %axis124(axis) @AS $MIRRORED;
*   #M124c(a) #M124d(b) %axis124(axis) @AS $MIRRORED;
*   #M124t {#M124a #M124b} @DISTANCE("bottom-to-top", min=2);
*   {#M124a #M124b} {#M124c #M124d} @DISTANCE("bottom-to-top", min=2);
*   %g125 = {#M125a #M125b #M125c #M125d #M125t} @GROUP;
*   %dp125 = #M125a(in_p) #M125b(in_n) #M125t(tail) @AS $DIFFERENTIAL_PAIR;
*   %cm125 = #M125c(ref) #M125d(out) @AS $CURRENT_MIRROR;
*   %axis125 = (_, _);
*   #M125a(a) #M125b(b) %axis125(axis) @AS $MIRRORED;
*   #M125c(a) #M125d(b) %axis125(axis) @AS $MIRRORED;
*   #M125t {#M125a #M125b} @DISTANCE("bottom-to-top", min=2);
*   {#M125a #M125b} {#M125c #M125d} @DISTANCE("bottom-to-top", min=2);
*   %g126 = {#M126a #M126b #M126c #M126d #M126t} @GROUP;
*   %dp126 = #M126a(in_p) #M126b(in_n) #M126t(tail) @AS $DIFFERENTIAL_PAIR;
*   %cm126 = #M126c(ref) #M126d(out) @AS $CURRENT_MIRROR;
*   %axis126 = (_, _);
*   #M126a(a) #M126b(b) %axis126(axis) @AS $MIRRORED;
*   #M126c(a) #M126d(b) %axis126(axis) @AS $MIRRORED;
*   #M126t {#M126a #M126b} @DISTANCE("bottom-to-top", min=2);
*   {#M126a #M126b} {#M126c #M126d} @DISTANCE("bottom-to-top", min=2);
*   %g127 = {#M127a #M127b #M127c #M127d #M127t} @GROUP;
*   %dp127 = #M127a(in_p) #M127b(in_n) #M127t(tail) @AS $DIFFERENTIAL_PAIR;
*   %cm127 = #M127c(ref) #M127d(out) @AS $CURRENT_MIRROR;
*   %axis127 = (_, _);
*   #M127a(a) #M127b(b) %axis127(axis) @AS $MIRRORED;
*   #M127c(a) #M127d(b) %axis127(axis) @AS $MIRRORED;
*   #M127t {#M127a #M127b} @DISTANCE("bottom-to-top", min=2);
*   {#M127a #M127b} {#M127c #M127d} @DISTANCE("bottom-to-top", min=2);
*   {%g0 %g1 %g2 %g3 %g4 %g5 %g6 %g7 %g8 %g9 %g10 %g11 %g12 %g13 %g14 %g15 %g16 %g17 %g18 %g19 %g20 %g21 %g22 %g23 %g24 %g25 %g26 %g27 %g28 %g29 %g30 %g31 %g32 %g33 %g34 %g35 %g36 %g37 %g38 %g39 %g40 %g41 %g42 %g43 %g44 %g45 %g46 %g47 %g48 %g49 %g50 %g51 %g52 %g53 %g54 %g55 %g56 %g57 %g58 %g59 %g60 %g61 %g62 %g63 %g64 %g65 %g66 %g67 %g68 %g69 %g70 %g71 %g72 %g73 %g74 %g75 %g76 %g77 %g78 %g79 %g80 %g81 %g82 %g83 %g84 %g85 %g86 %g87 %g88 %g89 %g90 %g91 %g92 %g93 %g94 %g95 %g96 %g97 %g98 %g99 %g100 %g101 %g102 %g103 %g104 %g105 %g106 %g107 %g108 %g109 %g110 %g111 %g112 %g113 %g114 %g115 %g116 %g117 %g118 %g119 %g120 %g121 %g122 %g123 %g124 %g125 %g126 %g127} @AS $FLOW;
*   $WIRE_NET_SET @ROUTE
* }
.end
