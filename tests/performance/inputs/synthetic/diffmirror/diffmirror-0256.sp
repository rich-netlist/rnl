* Synthetic diffmirror; n=256; generated by prepare_inputs.py
* @RNL(type="header") { @VERSION("0.3") }
.model nch nmos level=1
.model pch pmos level=1
M0a x0 inp0 tail0 vss nch W=2u L=0.5u
M0b out0 inn0 tail0 vss nch W=2u L=0.5u
M0c x0 x0 vdd vdd pch W=4u L=0.5u
M0d out0 x0 vdd vdd pch W=4u L=0.5u
M0t tail0 vbias vss vss nch W=4u L=1u
M1a x1 inp1 tail1 vss nch W=2u L=0.5u
M1b out1 inn1 tail1 vss nch W=2u L=0.5u
M1c x1 x1 vdd vdd pch W=4u L=0.5u
M1d out1 x1 vdd vdd pch W=4u L=0.5u
M1t tail1 vbias vss vss nch W=4u L=1u
M2a x2 inp2 tail2 vss nch W=2u L=0.5u
M2b out2 inn2 tail2 vss nch W=2u L=0.5u
M2c x2 x2 vdd vdd pch W=4u L=0.5u
M2d out2 x2 vdd vdd pch W=4u L=0.5u
M2t tail2 vbias vss vss nch W=4u L=1u
M3a x3 inp3 tail3 vss nch W=2u L=0.5u
M3b out3 inn3 tail3 vss nch W=2u L=0.5u
M3c x3 x3 vdd vdd pch W=4u L=0.5u
M3d out3 x3 vdd vdd pch W=4u L=0.5u
M3t tail3 vbias vss vss nch W=4u L=1u
M4a x4 inp4 tail4 vss nch W=2u L=0.5u
M4b out4 inn4 tail4 vss nch W=2u L=0.5u
M4c x4 x4 vdd vdd pch W=4u L=0.5u
M4d out4 x4 vdd vdd pch W=4u L=0.5u
M4t tail4 vbias vss vss nch W=4u L=1u
M5a x5 inp5 tail5 vss nch W=2u L=0.5u
M5b out5 inn5 tail5 vss nch W=2u L=0.5u
M5c x5 x5 vdd vdd pch W=4u L=0.5u
M5d out5 x5 vdd vdd pch W=4u L=0.5u
M5t tail5 vbias vss vss nch W=4u L=1u
M6a x6 inp6 tail6 vss nch W=2u L=0.5u
M6b out6 inn6 tail6 vss nch W=2u L=0.5u
M6c x6 x6 vdd vdd pch W=4u L=0.5u
M6d out6 x6 vdd vdd pch W=4u L=0.5u
M6t tail6 vbias vss vss nch W=4u L=1u
M7a x7 inp7 tail7 vss nch W=2u L=0.5u
M7b out7 inn7 tail7 vss nch W=2u L=0.5u
M7c x7 x7 vdd vdd pch W=4u L=0.5u
M7d out7 x7 vdd vdd pch W=4u L=0.5u
M7t tail7 vbias vss vss nch W=4u L=1u
M8a x8 inp8 tail8 vss nch W=2u L=0.5u
M8b out8 inn8 tail8 vss nch W=2u L=0.5u
M8c x8 x8 vdd vdd pch W=4u L=0.5u
M8d out8 x8 vdd vdd pch W=4u L=0.5u
M8t tail8 vbias vss vss nch W=4u L=1u
M9a x9 inp9 tail9 vss nch W=2u L=0.5u
M9b out9 inn9 tail9 vss nch W=2u L=0.5u
M9c x9 x9 vdd vdd pch W=4u L=0.5u
M9d out9 x9 vdd vdd pch W=4u L=0.5u
M9t tail9 vbias vss vss nch W=4u L=1u
M10a x10 inp10 tail10 vss nch W=2u L=0.5u
M10b out10 inn10 tail10 vss nch W=2u L=0.5u
M10c x10 x10 vdd vdd pch W=4u L=0.5u
M10d out10 x10 vdd vdd pch W=4u L=0.5u
M10t tail10 vbias vss vss nch W=4u L=1u
M11a x11 inp11 tail11 vss nch W=2u L=0.5u
M11b out11 inn11 tail11 vss nch W=2u L=0.5u
M11c x11 x11 vdd vdd pch W=4u L=0.5u
M11d out11 x11 vdd vdd pch W=4u L=0.5u
M11t tail11 vbias vss vss nch W=4u L=1u
M12a x12 inp12 tail12 vss nch W=2u L=0.5u
M12b out12 inn12 tail12 vss nch W=2u L=0.5u
M12c x12 x12 vdd vdd pch W=4u L=0.5u
M12d out12 x12 vdd vdd pch W=4u L=0.5u
M12t tail12 vbias vss vss nch W=4u L=1u
M13a x13 inp13 tail13 vss nch W=2u L=0.5u
M13b out13 inn13 tail13 vss nch W=2u L=0.5u
M13c x13 x13 vdd vdd pch W=4u L=0.5u
M13d out13 x13 vdd vdd pch W=4u L=0.5u
M13t tail13 vbias vss vss nch W=4u L=1u
M14a x14 inp14 tail14 vss nch W=2u L=0.5u
M14b out14 inn14 tail14 vss nch W=2u L=0.5u
M14c x14 x14 vdd vdd pch W=4u L=0.5u
M14d out14 x14 vdd vdd pch W=4u L=0.5u
M14t tail14 vbias vss vss nch W=4u L=1u
M15a x15 inp15 tail15 vss nch W=2u L=0.5u
M15b out15 inn15 tail15 vss nch W=2u L=0.5u
M15c x15 x15 vdd vdd pch W=4u L=0.5u
M15d out15 x15 vdd vdd pch W=4u L=0.5u
M15t tail15 vbias vss vss nch W=4u L=1u
M16a x16 inp16 tail16 vss nch W=2u L=0.5u
M16b out16 inn16 tail16 vss nch W=2u L=0.5u
M16c x16 x16 vdd vdd pch W=4u L=0.5u
M16d out16 x16 vdd vdd pch W=4u L=0.5u
M16t tail16 vbias vss vss nch W=4u L=1u
M17a x17 inp17 tail17 vss nch W=2u L=0.5u
M17b out17 inn17 tail17 vss nch W=2u L=0.5u
M17c x17 x17 vdd vdd pch W=4u L=0.5u
M17d out17 x17 vdd vdd pch W=4u L=0.5u
M17t tail17 vbias vss vss nch W=4u L=1u
M18a x18 inp18 tail18 vss nch W=2u L=0.5u
M18b out18 inn18 tail18 vss nch W=2u L=0.5u
M18c x18 x18 vdd vdd pch W=4u L=0.5u
M18d out18 x18 vdd vdd pch W=4u L=0.5u
M18t tail18 vbias vss vss nch W=4u L=1u
M19a x19 inp19 tail19 vss nch W=2u L=0.5u
M19b out19 inn19 tail19 vss nch W=2u L=0.5u
M19c x19 x19 vdd vdd pch W=4u L=0.5u
M19d out19 x19 vdd vdd pch W=4u L=0.5u
M19t tail19 vbias vss vss nch W=4u L=1u
M20a x20 inp20 tail20 vss nch W=2u L=0.5u
M20b out20 inn20 tail20 vss nch W=2u L=0.5u
M20c x20 x20 vdd vdd pch W=4u L=0.5u
M20d out20 x20 vdd vdd pch W=4u L=0.5u
M20t tail20 vbias vss vss nch W=4u L=1u
M21a x21 inp21 tail21 vss nch W=2u L=0.5u
M21b out21 inn21 tail21 vss nch W=2u L=0.5u
M21c x21 x21 vdd vdd pch W=4u L=0.5u
M21d out21 x21 vdd vdd pch W=4u L=0.5u
M21t tail21 vbias vss vss nch W=4u L=1u
M22a x22 inp22 tail22 vss nch W=2u L=0.5u
M22b out22 inn22 tail22 vss nch W=2u L=0.5u
M22c x22 x22 vdd vdd pch W=4u L=0.5u
M22d out22 x22 vdd vdd pch W=4u L=0.5u
M22t tail22 vbias vss vss nch W=4u L=1u
M23a x23 inp23 tail23 vss nch W=2u L=0.5u
M23b out23 inn23 tail23 vss nch W=2u L=0.5u
M23c x23 x23 vdd vdd pch W=4u L=0.5u
M23d out23 x23 vdd vdd pch W=4u L=0.5u
M23t tail23 vbias vss vss nch W=4u L=1u
M24a x24 inp24 tail24 vss nch W=2u L=0.5u
M24b out24 inn24 tail24 vss nch W=2u L=0.5u
M24c x24 x24 vdd vdd pch W=4u L=0.5u
M24d out24 x24 vdd vdd pch W=4u L=0.5u
M24t tail24 vbias vss vss nch W=4u L=1u
M25a x25 inp25 tail25 vss nch W=2u L=0.5u
M25b out25 inn25 tail25 vss nch W=2u L=0.5u
M25c x25 x25 vdd vdd pch W=4u L=0.5u
M25d out25 x25 vdd vdd pch W=4u L=0.5u
M25t tail25 vbias vss vss nch W=4u L=1u
M26a x26 inp26 tail26 vss nch W=2u L=0.5u
M26b out26 inn26 tail26 vss nch W=2u L=0.5u
M26c x26 x26 vdd vdd pch W=4u L=0.5u
M26d out26 x26 vdd vdd pch W=4u L=0.5u
M26t tail26 vbias vss vss nch W=4u L=1u
M27a x27 inp27 tail27 vss nch W=2u L=0.5u
M27b out27 inn27 tail27 vss nch W=2u L=0.5u
M27c x27 x27 vdd vdd pch W=4u L=0.5u
M27d out27 x27 vdd vdd pch W=4u L=0.5u
M27t tail27 vbias vss vss nch W=4u L=1u
M28a x28 inp28 tail28 vss nch W=2u L=0.5u
M28b out28 inn28 tail28 vss nch W=2u L=0.5u
M28c x28 x28 vdd vdd pch W=4u L=0.5u
M28d out28 x28 vdd vdd pch W=4u L=0.5u
M28t tail28 vbias vss vss nch W=4u L=1u
M29a x29 inp29 tail29 vss nch W=2u L=0.5u
M29b out29 inn29 tail29 vss nch W=2u L=0.5u
M29c x29 x29 vdd vdd pch W=4u L=0.5u
M29d out29 x29 vdd vdd pch W=4u L=0.5u
M29t tail29 vbias vss vss nch W=4u L=1u
M30a x30 inp30 tail30 vss nch W=2u L=0.5u
M30b out30 inn30 tail30 vss nch W=2u L=0.5u
M30c x30 x30 vdd vdd pch W=4u L=0.5u
M30d out30 x30 vdd vdd pch W=4u L=0.5u
M30t tail30 vbias vss vss nch W=4u L=1u
M31a x31 inp31 tail31 vss nch W=2u L=0.5u
M31b out31 inn31 tail31 vss nch W=2u L=0.5u
M31c x31 x31 vdd vdd pch W=4u L=0.5u
M31d out31 x31 vdd vdd pch W=4u L=0.5u
M31t tail31 vbias vss vss nch W=4u L=1u
M32a x32 inp32 tail32 vss nch W=2u L=0.5u
M32b out32 inn32 tail32 vss nch W=2u L=0.5u
M32c x32 x32 vdd vdd pch W=4u L=0.5u
M32d out32 x32 vdd vdd pch W=4u L=0.5u
M32t tail32 vbias vss vss nch W=4u L=1u
M33a x33 inp33 tail33 vss nch W=2u L=0.5u
M33b out33 inn33 tail33 vss nch W=2u L=0.5u
M33c x33 x33 vdd vdd pch W=4u L=0.5u
M33d out33 x33 vdd vdd pch W=4u L=0.5u
M33t tail33 vbias vss vss nch W=4u L=1u
M34a x34 inp34 tail34 vss nch W=2u L=0.5u
M34b out34 inn34 tail34 vss nch W=2u L=0.5u
M34c x34 x34 vdd vdd pch W=4u L=0.5u
M34d out34 x34 vdd vdd pch W=4u L=0.5u
M34t tail34 vbias vss vss nch W=4u L=1u
M35a x35 inp35 tail35 vss nch W=2u L=0.5u
M35b out35 inn35 tail35 vss nch W=2u L=0.5u
M35c x35 x35 vdd vdd pch W=4u L=0.5u
M35d out35 x35 vdd vdd pch W=4u L=0.5u
M35t tail35 vbias vss vss nch W=4u L=1u
M36a x36 inp36 tail36 vss nch W=2u L=0.5u
M36b out36 inn36 tail36 vss nch W=2u L=0.5u
M36c x36 x36 vdd vdd pch W=4u L=0.5u
M36d out36 x36 vdd vdd pch W=4u L=0.5u
M36t tail36 vbias vss vss nch W=4u L=1u
M37a x37 inp37 tail37 vss nch W=2u L=0.5u
M37b out37 inn37 tail37 vss nch W=2u L=0.5u
M37c x37 x37 vdd vdd pch W=4u L=0.5u
M37d out37 x37 vdd vdd pch W=4u L=0.5u
M37t tail37 vbias vss vss nch W=4u L=1u
M38a x38 inp38 tail38 vss nch W=2u L=0.5u
M38b out38 inn38 tail38 vss nch W=2u L=0.5u
M38c x38 x38 vdd vdd pch W=4u L=0.5u
M38d out38 x38 vdd vdd pch W=4u L=0.5u
M38t tail38 vbias vss vss nch W=4u L=1u
M39a x39 inp39 tail39 vss nch W=2u L=0.5u
M39b out39 inn39 tail39 vss nch W=2u L=0.5u
M39c x39 x39 vdd vdd pch W=4u L=0.5u
M39d out39 x39 vdd vdd pch W=4u L=0.5u
M39t tail39 vbias vss vss nch W=4u L=1u
M40a x40 inp40 tail40 vss nch W=2u L=0.5u
M40b out40 inn40 tail40 vss nch W=2u L=0.5u
M40c x40 x40 vdd vdd pch W=4u L=0.5u
M40d out40 x40 vdd vdd pch W=4u L=0.5u
M40t tail40 vbias vss vss nch W=4u L=1u
M41a x41 inp41 tail41 vss nch W=2u L=0.5u
M41b out41 inn41 tail41 vss nch W=2u L=0.5u
M41c x41 x41 vdd vdd pch W=4u L=0.5u
M41d out41 x41 vdd vdd pch W=4u L=0.5u
M41t tail41 vbias vss vss nch W=4u L=1u
M42a x42 inp42 tail42 vss nch W=2u L=0.5u
M42b out42 inn42 tail42 vss nch W=2u L=0.5u
M42c x42 x42 vdd vdd pch W=4u L=0.5u
M42d out42 x42 vdd vdd pch W=4u L=0.5u
M42t tail42 vbias vss vss nch W=4u L=1u
M43a x43 inp43 tail43 vss nch W=2u L=0.5u
M43b out43 inn43 tail43 vss nch W=2u L=0.5u
M43c x43 x43 vdd vdd pch W=4u L=0.5u
M43d out43 x43 vdd vdd pch W=4u L=0.5u
M43t tail43 vbias vss vss nch W=4u L=1u
M44a x44 inp44 tail44 vss nch W=2u L=0.5u
M44b out44 inn44 tail44 vss nch W=2u L=0.5u
M44c x44 x44 vdd vdd pch W=4u L=0.5u
M44d out44 x44 vdd vdd pch W=4u L=0.5u
M44t tail44 vbias vss vss nch W=4u L=1u
M45a x45 inp45 tail45 vss nch W=2u L=0.5u
M45b out45 inn45 tail45 vss nch W=2u L=0.5u
M45c x45 x45 vdd vdd pch W=4u L=0.5u
M45d out45 x45 vdd vdd pch W=4u L=0.5u
M45t tail45 vbias vss vss nch W=4u L=1u
M46a x46 inp46 tail46 vss nch W=2u L=0.5u
M46b out46 inn46 tail46 vss nch W=2u L=0.5u
M46c x46 x46 vdd vdd pch W=4u L=0.5u
M46d out46 x46 vdd vdd pch W=4u L=0.5u
M46t tail46 vbias vss vss nch W=4u L=1u
M47a x47 inp47 tail47 vss nch W=2u L=0.5u
M47b out47 inn47 tail47 vss nch W=2u L=0.5u
M47c x47 x47 vdd vdd pch W=4u L=0.5u
M47d out47 x47 vdd vdd pch W=4u L=0.5u
M47t tail47 vbias vss vss nch W=4u L=1u
M48a x48 inp48 tail48 vss nch W=2u L=0.5u
M48b out48 inn48 tail48 vss nch W=2u L=0.5u
M48c x48 x48 vdd vdd pch W=4u L=0.5u
M48d out48 x48 vdd vdd pch W=4u L=0.5u
M48t tail48 vbias vss vss nch W=4u L=1u
M49a x49 inp49 tail49 vss nch W=2u L=0.5u
M49b out49 inn49 tail49 vss nch W=2u L=0.5u
M49c x49 x49 vdd vdd pch W=4u L=0.5u
M49d out49 x49 vdd vdd pch W=4u L=0.5u
M49t tail49 vbias vss vss nch W=4u L=1u
M50a x50 inp50 tail50 vss nch W=2u L=0.5u
M50b out50 inn50 tail50 vss nch W=2u L=0.5u
M50c x50 x50 vdd vdd pch W=4u L=0.5u
M50d out50 x50 vdd vdd pch W=4u L=0.5u
M50t tail50 vbias vss vss nch W=4u L=1u
M51a x51 inp51 tail51 vss nch W=2u L=0.5u
M51b out51 inn51 tail51 vss nch W=2u L=0.5u
M51c x51 x51 vdd vdd pch W=4u L=0.5u
M51d out51 x51 vdd vdd pch W=4u L=0.5u
M51t tail51 vbias vss vss nch W=4u L=1u
M52a x52 inp52 tail52 vss nch W=2u L=0.5u
M52b out52 inn52 tail52 vss nch W=2u L=0.5u
M52c x52 x52 vdd vdd pch W=4u L=0.5u
M52d out52 x52 vdd vdd pch W=4u L=0.5u
M52t tail52 vbias vss vss nch W=4u L=1u
M53a x53 inp53 tail53 vss nch W=2u L=0.5u
M53b out53 inn53 tail53 vss nch W=2u L=0.5u
M53c x53 x53 vdd vdd pch W=4u L=0.5u
M53d out53 x53 vdd vdd pch W=4u L=0.5u
M53t tail53 vbias vss vss nch W=4u L=1u
M54a x54 inp54 tail54 vss nch W=2u L=0.5u
M54b out54 inn54 tail54 vss nch W=2u L=0.5u
M54c x54 x54 vdd vdd pch W=4u L=0.5u
M54d out54 x54 vdd vdd pch W=4u L=0.5u
M54t tail54 vbias vss vss nch W=4u L=1u
M55a x55 inp55 tail55 vss nch W=2u L=0.5u
M55b out55 inn55 tail55 vss nch W=2u L=0.5u
M55c x55 x55 vdd vdd pch W=4u L=0.5u
M55d out55 x55 vdd vdd pch W=4u L=0.5u
M55t tail55 vbias vss vss nch W=4u L=1u
M56a x56 inp56 tail56 vss nch W=2u L=0.5u
M56b out56 inn56 tail56 vss nch W=2u L=0.5u
M56c x56 x56 vdd vdd pch W=4u L=0.5u
M56d out56 x56 vdd vdd pch W=4u L=0.5u
M56t tail56 vbias vss vss nch W=4u L=1u
M57a x57 inp57 tail57 vss nch W=2u L=0.5u
M57b out57 inn57 tail57 vss nch W=2u L=0.5u
M57c x57 x57 vdd vdd pch W=4u L=0.5u
M57d out57 x57 vdd vdd pch W=4u L=0.5u
M57t tail57 vbias vss vss nch W=4u L=1u
M58a x58 inp58 tail58 vss nch W=2u L=0.5u
M58b out58 inn58 tail58 vss nch W=2u L=0.5u
M58c x58 x58 vdd vdd pch W=4u L=0.5u
M58d out58 x58 vdd vdd pch W=4u L=0.5u
M58t tail58 vbias vss vss nch W=4u L=1u
M59a x59 inp59 tail59 vss nch W=2u L=0.5u
M59b out59 inn59 tail59 vss nch W=2u L=0.5u
M59c x59 x59 vdd vdd pch W=4u L=0.5u
M59d out59 x59 vdd vdd pch W=4u L=0.5u
M59t tail59 vbias vss vss nch W=4u L=1u
M60a x60 inp60 tail60 vss nch W=2u L=0.5u
M60b out60 inn60 tail60 vss nch W=2u L=0.5u
M60c x60 x60 vdd vdd pch W=4u L=0.5u
M60d out60 x60 vdd vdd pch W=4u L=0.5u
M60t tail60 vbias vss vss nch W=4u L=1u
M61a x61 inp61 tail61 vss nch W=2u L=0.5u
M61b out61 inn61 tail61 vss nch W=2u L=0.5u
M61c x61 x61 vdd vdd pch W=4u L=0.5u
M61d out61 x61 vdd vdd pch W=4u L=0.5u
M61t tail61 vbias vss vss nch W=4u L=1u
M62a x62 inp62 tail62 vss nch W=2u L=0.5u
M62b out62 inn62 tail62 vss nch W=2u L=0.5u
M62c x62 x62 vdd vdd pch W=4u L=0.5u
M62d out62 x62 vdd vdd pch W=4u L=0.5u
M62t tail62 vbias vss vss nch W=4u L=1u
M63a x63 inp63 tail63 vss nch W=2u L=0.5u
M63b out63 inn63 tail63 vss nch W=2u L=0.5u
M63c x63 x63 vdd vdd pch W=4u L=0.5u
M63d out63 x63 vdd vdd pch W=4u L=0.5u
M63t tail63 vbias vss vss nch W=4u L=1u
M64a x64 inp64 tail64 vss nch W=2u L=0.5u
M64b out64 inn64 tail64 vss nch W=2u L=0.5u
M64c x64 x64 vdd vdd pch W=4u L=0.5u
M64d out64 x64 vdd vdd pch W=4u L=0.5u
M64t tail64 vbias vss vss nch W=4u L=1u
M65a x65 inp65 tail65 vss nch W=2u L=0.5u
M65b out65 inn65 tail65 vss nch W=2u L=0.5u
M65c x65 x65 vdd vdd pch W=4u L=0.5u
M65d out65 x65 vdd vdd pch W=4u L=0.5u
M65t tail65 vbias vss vss nch W=4u L=1u
M66a x66 inp66 tail66 vss nch W=2u L=0.5u
M66b out66 inn66 tail66 vss nch W=2u L=0.5u
M66c x66 x66 vdd vdd pch W=4u L=0.5u
M66d out66 x66 vdd vdd pch W=4u L=0.5u
M66t tail66 vbias vss vss nch W=4u L=1u
M67a x67 inp67 tail67 vss nch W=2u L=0.5u
M67b out67 inn67 tail67 vss nch W=2u L=0.5u
M67c x67 x67 vdd vdd pch W=4u L=0.5u
M67d out67 x67 vdd vdd pch W=4u L=0.5u
M67t tail67 vbias vss vss nch W=4u L=1u
M68a x68 inp68 tail68 vss nch W=2u L=0.5u
M68b out68 inn68 tail68 vss nch W=2u L=0.5u
M68c x68 x68 vdd vdd pch W=4u L=0.5u
M68d out68 x68 vdd vdd pch W=4u L=0.5u
M68t tail68 vbias vss vss nch W=4u L=1u
M69a x69 inp69 tail69 vss nch W=2u L=0.5u
M69b out69 inn69 tail69 vss nch W=2u L=0.5u
M69c x69 x69 vdd vdd pch W=4u L=0.5u
M69d out69 x69 vdd vdd pch W=4u L=0.5u
M69t tail69 vbias vss vss nch W=4u L=1u
M70a x70 inp70 tail70 vss nch W=2u L=0.5u
M70b out70 inn70 tail70 vss nch W=2u L=0.5u
M70c x70 x70 vdd vdd pch W=4u L=0.5u
M70d out70 x70 vdd vdd pch W=4u L=0.5u
M70t tail70 vbias vss vss nch W=4u L=1u
M71a x71 inp71 tail71 vss nch W=2u L=0.5u
M71b out71 inn71 tail71 vss nch W=2u L=0.5u
M71c x71 x71 vdd vdd pch W=4u L=0.5u
M71d out71 x71 vdd vdd pch W=4u L=0.5u
M71t tail71 vbias vss vss nch W=4u L=1u
M72a x72 inp72 tail72 vss nch W=2u L=0.5u
M72b out72 inn72 tail72 vss nch W=2u L=0.5u
M72c x72 x72 vdd vdd pch W=4u L=0.5u
M72d out72 x72 vdd vdd pch W=4u L=0.5u
M72t tail72 vbias vss vss nch W=4u L=1u
M73a x73 inp73 tail73 vss nch W=2u L=0.5u
M73b out73 inn73 tail73 vss nch W=2u L=0.5u
M73c x73 x73 vdd vdd pch W=4u L=0.5u
M73d out73 x73 vdd vdd pch W=4u L=0.5u
M73t tail73 vbias vss vss nch W=4u L=1u
M74a x74 inp74 tail74 vss nch W=2u L=0.5u
M74b out74 inn74 tail74 vss nch W=2u L=0.5u
M74c x74 x74 vdd vdd pch W=4u L=0.5u
M74d out74 x74 vdd vdd pch W=4u L=0.5u
M74t tail74 vbias vss vss nch W=4u L=1u
M75a x75 inp75 tail75 vss nch W=2u L=0.5u
M75b out75 inn75 tail75 vss nch W=2u L=0.5u
M75c x75 x75 vdd vdd pch W=4u L=0.5u
M75d out75 x75 vdd vdd pch W=4u L=0.5u
M75t tail75 vbias vss vss nch W=4u L=1u
M76a x76 inp76 tail76 vss nch W=2u L=0.5u
M76b out76 inn76 tail76 vss nch W=2u L=0.5u
M76c x76 x76 vdd vdd pch W=4u L=0.5u
M76d out76 x76 vdd vdd pch W=4u L=0.5u
M76t tail76 vbias vss vss nch W=4u L=1u
M77a x77 inp77 tail77 vss nch W=2u L=0.5u
M77b out77 inn77 tail77 vss nch W=2u L=0.5u
M77c x77 x77 vdd vdd pch W=4u L=0.5u
M77d out77 x77 vdd vdd pch W=4u L=0.5u
M77t tail77 vbias vss vss nch W=4u L=1u
M78a x78 inp78 tail78 vss nch W=2u L=0.5u
M78b out78 inn78 tail78 vss nch W=2u L=0.5u
M78c x78 x78 vdd vdd pch W=4u L=0.5u
M78d out78 x78 vdd vdd pch W=4u L=0.5u
M78t tail78 vbias vss vss nch W=4u L=1u
M79a x79 inp79 tail79 vss nch W=2u L=0.5u
M79b out79 inn79 tail79 vss nch W=2u L=0.5u
M79c x79 x79 vdd vdd pch W=4u L=0.5u
M79d out79 x79 vdd vdd pch W=4u L=0.5u
M79t tail79 vbias vss vss nch W=4u L=1u
M80a x80 inp80 tail80 vss nch W=2u L=0.5u
M80b out80 inn80 tail80 vss nch W=2u L=0.5u
M80c x80 x80 vdd vdd pch W=4u L=0.5u
M80d out80 x80 vdd vdd pch W=4u L=0.5u
M80t tail80 vbias vss vss nch W=4u L=1u
M81a x81 inp81 tail81 vss nch W=2u L=0.5u
M81b out81 inn81 tail81 vss nch W=2u L=0.5u
M81c x81 x81 vdd vdd pch W=4u L=0.5u
M81d out81 x81 vdd vdd pch W=4u L=0.5u
M81t tail81 vbias vss vss nch W=4u L=1u
M82a x82 inp82 tail82 vss nch W=2u L=0.5u
M82b out82 inn82 tail82 vss nch W=2u L=0.5u
M82c x82 x82 vdd vdd pch W=4u L=0.5u
M82d out82 x82 vdd vdd pch W=4u L=0.5u
M82t tail82 vbias vss vss nch W=4u L=1u
M83a x83 inp83 tail83 vss nch W=2u L=0.5u
M83b out83 inn83 tail83 vss nch W=2u L=0.5u
M83c x83 x83 vdd vdd pch W=4u L=0.5u
M83d out83 x83 vdd vdd pch W=4u L=0.5u
M83t tail83 vbias vss vss nch W=4u L=1u
M84a x84 inp84 tail84 vss nch W=2u L=0.5u
M84b out84 inn84 tail84 vss nch W=2u L=0.5u
M84c x84 x84 vdd vdd pch W=4u L=0.5u
M84d out84 x84 vdd vdd pch W=4u L=0.5u
M84t tail84 vbias vss vss nch W=4u L=1u
M85a x85 inp85 tail85 vss nch W=2u L=0.5u
M85b out85 inn85 tail85 vss nch W=2u L=0.5u
M85c x85 x85 vdd vdd pch W=4u L=0.5u
M85d out85 x85 vdd vdd pch W=4u L=0.5u
M85t tail85 vbias vss vss nch W=4u L=1u
M86a x86 inp86 tail86 vss nch W=2u L=0.5u
M86b out86 inn86 tail86 vss nch W=2u L=0.5u
M86c x86 x86 vdd vdd pch W=4u L=0.5u
M86d out86 x86 vdd vdd pch W=4u L=0.5u
M86t tail86 vbias vss vss nch W=4u L=1u
M87a x87 inp87 tail87 vss nch W=2u L=0.5u
M87b out87 inn87 tail87 vss nch W=2u L=0.5u
M87c x87 x87 vdd vdd pch W=4u L=0.5u
M87d out87 x87 vdd vdd pch W=4u L=0.5u
M87t tail87 vbias vss vss nch W=4u L=1u
M88a x88 inp88 tail88 vss nch W=2u L=0.5u
M88b out88 inn88 tail88 vss nch W=2u L=0.5u
M88c x88 x88 vdd vdd pch W=4u L=0.5u
M88d out88 x88 vdd vdd pch W=4u L=0.5u
M88t tail88 vbias vss vss nch W=4u L=1u
M89a x89 inp89 tail89 vss nch W=2u L=0.5u
M89b out89 inn89 tail89 vss nch W=2u L=0.5u
M89c x89 x89 vdd vdd pch W=4u L=0.5u
M89d out89 x89 vdd vdd pch W=4u L=0.5u
M89t tail89 vbias vss vss nch W=4u L=1u
M90a x90 inp90 tail90 vss nch W=2u L=0.5u
M90b out90 inn90 tail90 vss nch W=2u L=0.5u
M90c x90 x90 vdd vdd pch W=4u L=0.5u
M90d out90 x90 vdd vdd pch W=4u L=0.5u
M90t tail90 vbias vss vss nch W=4u L=1u
M91a x91 inp91 tail91 vss nch W=2u L=0.5u
M91b out91 inn91 tail91 vss nch W=2u L=0.5u
M91c x91 x91 vdd vdd pch W=4u L=0.5u
M91d out91 x91 vdd vdd pch W=4u L=0.5u
M91t tail91 vbias vss vss nch W=4u L=1u
M92a x92 inp92 tail92 vss nch W=2u L=0.5u
M92b out92 inn92 tail92 vss nch W=2u L=0.5u
M92c x92 x92 vdd vdd pch W=4u L=0.5u
M92d out92 x92 vdd vdd pch W=4u L=0.5u
M92t tail92 vbias vss vss nch W=4u L=1u
M93a x93 inp93 tail93 vss nch W=2u L=0.5u
M93b out93 inn93 tail93 vss nch W=2u L=0.5u
M93c x93 x93 vdd vdd pch W=4u L=0.5u
M93d out93 x93 vdd vdd pch W=4u L=0.5u
M93t tail93 vbias vss vss nch W=4u L=1u
M94a x94 inp94 tail94 vss nch W=2u L=0.5u
M94b out94 inn94 tail94 vss nch W=2u L=0.5u
M94c x94 x94 vdd vdd pch W=4u L=0.5u
M94d out94 x94 vdd vdd pch W=4u L=0.5u
M94t tail94 vbias vss vss nch W=4u L=1u
M95a x95 inp95 tail95 vss nch W=2u L=0.5u
M95b out95 inn95 tail95 vss nch W=2u L=0.5u
M95c x95 x95 vdd vdd pch W=4u L=0.5u
M95d out95 x95 vdd vdd pch W=4u L=0.5u
M95t tail95 vbias vss vss nch W=4u L=1u
M96a x96 inp96 tail96 vss nch W=2u L=0.5u
M96b out96 inn96 tail96 vss nch W=2u L=0.5u
M96c x96 x96 vdd vdd pch W=4u L=0.5u
M96d out96 x96 vdd vdd pch W=4u L=0.5u
M96t tail96 vbias vss vss nch W=4u L=1u
M97a x97 inp97 tail97 vss nch W=2u L=0.5u
M97b out97 inn97 tail97 vss nch W=2u L=0.5u
M97c x97 x97 vdd vdd pch W=4u L=0.5u
M97d out97 x97 vdd vdd pch W=4u L=0.5u
M97t tail97 vbias vss vss nch W=4u L=1u
M98a x98 inp98 tail98 vss nch W=2u L=0.5u
M98b out98 inn98 tail98 vss nch W=2u L=0.5u
M98c x98 x98 vdd vdd pch W=4u L=0.5u
M98d out98 x98 vdd vdd pch W=4u L=0.5u
M98t tail98 vbias vss vss nch W=4u L=1u
M99a x99 inp99 tail99 vss nch W=2u L=0.5u
M99b out99 inn99 tail99 vss nch W=2u L=0.5u
M99c x99 x99 vdd vdd pch W=4u L=0.5u
M99d out99 x99 vdd vdd pch W=4u L=0.5u
M99t tail99 vbias vss vss nch W=4u L=1u
M100a x100 inp100 tail100 vss nch W=2u L=0.5u
M100b out100 inn100 tail100 vss nch W=2u L=0.5u
M100c x100 x100 vdd vdd pch W=4u L=0.5u
M100d out100 x100 vdd vdd pch W=4u L=0.5u
M100t tail100 vbias vss vss nch W=4u L=1u
M101a x101 inp101 tail101 vss nch W=2u L=0.5u
M101b out101 inn101 tail101 vss nch W=2u L=0.5u
M101c x101 x101 vdd vdd pch W=4u L=0.5u
M101d out101 x101 vdd vdd pch W=4u L=0.5u
M101t tail101 vbias vss vss nch W=4u L=1u
M102a x102 inp102 tail102 vss nch W=2u L=0.5u
M102b out102 inn102 tail102 vss nch W=2u L=0.5u
M102c x102 x102 vdd vdd pch W=4u L=0.5u
M102d out102 x102 vdd vdd pch W=4u L=0.5u
M102t tail102 vbias vss vss nch W=4u L=1u
M103a x103 inp103 tail103 vss nch W=2u L=0.5u
M103b out103 inn103 tail103 vss nch W=2u L=0.5u
M103c x103 x103 vdd vdd pch W=4u L=0.5u
M103d out103 x103 vdd vdd pch W=4u L=0.5u
M103t tail103 vbias vss vss nch W=4u L=1u
M104a x104 inp104 tail104 vss nch W=2u L=0.5u
M104b out104 inn104 tail104 vss nch W=2u L=0.5u
M104c x104 x104 vdd vdd pch W=4u L=0.5u
M104d out104 x104 vdd vdd pch W=4u L=0.5u
M104t tail104 vbias vss vss nch W=4u L=1u
M105a x105 inp105 tail105 vss nch W=2u L=0.5u
M105b out105 inn105 tail105 vss nch W=2u L=0.5u
M105c x105 x105 vdd vdd pch W=4u L=0.5u
M105d out105 x105 vdd vdd pch W=4u L=0.5u
M105t tail105 vbias vss vss nch W=4u L=1u
M106a x106 inp106 tail106 vss nch W=2u L=0.5u
M106b out106 inn106 tail106 vss nch W=2u L=0.5u
M106c x106 x106 vdd vdd pch W=4u L=0.5u
M106d out106 x106 vdd vdd pch W=4u L=0.5u
M106t tail106 vbias vss vss nch W=4u L=1u
M107a x107 inp107 tail107 vss nch W=2u L=0.5u
M107b out107 inn107 tail107 vss nch W=2u L=0.5u
M107c x107 x107 vdd vdd pch W=4u L=0.5u
M107d out107 x107 vdd vdd pch W=4u L=0.5u
M107t tail107 vbias vss vss nch W=4u L=1u
M108a x108 inp108 tail108 vss nch W=2u L=0.5u
M108b out108 inn108 tail108 vss nch W=2u L=0.5u
M108c x108 x108 vdd vdd pch W=4u L=0.5u
M108d out108 x108 vdd vdd pch W=4u L=0.5u
M108t tail108 vbias vss vss nch W=4u L=1u
M109a x109 inp109 tail109 vss nch W=2u L=0.5u
M109b out109 inn109 tail109 vss nch W=2u L=0.5u
M109c x109 x109 vdd vdd pch W=4u L=0.5u
M109d out109 x109 vdd vdd pch W=4u L=0.5u
M109t tail109 vbias vss vss nch W=4u L=1u
M110a x110 inp110 tail110 vss nch W=2u L=0.5u
M110b out110 inn110 tail110 vss nch W=2u L=0.5u
M110c x110 x110 vdd vdd pch W=4u L=0.5u
M110d out110 x110 vdd vdd pch W=4u L=0.5u
M110t tail110 vbias vss vss nch W=4u L=1u
M111a x111 inp111 tail111 vss nch W=2u L=0.5u
M111b out111 inn111 tail111 vss nch W=2u L=0.5u
M111c x111 x111 vdd vdd pch W=4u L=0.5u
M111d out111 x111 vdd vdd pch W=4u L=0.5u
M111t tail111 vbias vss vss nch W=4u L=1u
M112a x112 inp112 tail112 vss nch W=2u L=0.5u
M112b out112 inn112 tail112 vss nch W=2u L=0.5u
M112c x112 x112 vdd vdd pch W=4u L=0.5u
M112d out112 x112 vdd vdd pch W=4u L=0.5u
M112t tail112 vbias vss vss nch W=4u L=1u
M113a x113 inp113 tail113 vss nch W=2u L=0.5u
M113b out113 inn113 tail113 vss nch W=2u L=0.5u
M113c x113 x113 vdd vdd pch W=4u L=0.5u
M113d out113 x113 vdd vdd pch W=4u L=0.5u
M113t tail113 vbias vss vss nch W=4u L=1u
M114a x114 inp114 tail114 vss nch W=2u L=0.5u
M114b out114 inn114 tail114 vss nch W=2u L=0.5u
M114c x114 x114 vdd vdd pch W=4u L=0.5u
M114d out114 x114 vdd vdd pch W=4u L=0.5u
M114t tail114 vbias vss vss nch W=4u L=1u
M115a x115 inp115 tail115 vss nch W=2u L=0.5u
M115b out115 inn115 tail115 vss nch W=2u L=0.5u
M115c x115 x115 vdd vdd pch W=4u L=0.5u
M115d out115 x115 vdd vdd pch W=4u L=0.5u
M115t tail115 vbias vss vss nch W=4u L=1u
M116a x116 inp116 tail116 vss nch W=2u L=0.5u
M116b out116 inn116 tail116 vss nch W=2u L=0.5u
M116c x116 x116 vdd vdd pch W=4u L=0.5u
M116d out116 x116 vdd vdd pch W=4u L=0.5u
M116t tail116 vbias vss vss nch W=4u L=1u
M117a x117 inp117 tail117 vss nch W=2u L=0.5u
M117b out117 inn117 tail117 vss nch W=2u L=0.5u
M117c x117 x117 vdd vdd pch W=4u L=0.5u
M117d out117 x117 vdd vdd pch W=4u L=0.5u
M117t tail117 vbias vss vss nch W=4u L=1u
M118a x118 inp118 tail118 vss nch W=2u L=0.5u
M118b out118 inn118 tail118 vss nch W=2u L=0.5u
M118c x118 x118 vdd vdd pch W=4u L=0.5u
M118d out118 x118 vdd vdd pch W=4u L=0.5u
M118t tail118 vbias vss vss nch W=4u L=1u
M119a x119 inp119 tail119 vss nch W=2u L=0.5u
M119b out119 inn119 tail119 vss nch W=2u L=0.5u
M119c x119 x119 vdd vdd pch W=4u L=0.5u
M119d out119 x119 vdd vdd pch W=4u L=0.5u
M119t tail119 vbias vss vss nch W=4u L=1u
M120a x120 inp120 tail120 vss nch W=2u L=0.5u
M120b out120 inn120 tail120 vss nch W=2u L=0.5u
M120c x120 x120 vdd vdd pch W=4u L=0.5u
M120d out120 x120 vdd vdd pch W=4u L=0.5u
M120t tail120 vbias vss vss nch W=4u L=1u
M121a x121 inp121 tail121 vss nch W=2u L=0.5u
M121b out121 inn121 tail121 vss nch W=2u L=0.5u
M121c x121 x121 vdd vdd pch W=4u L=0.5u
M121d out121 x121 vdd vdd pch W=4u L=0.5u
M121t tail121 vbias vss vss nch W=4u L=1u
M122a x122 inp122 tail122 vss nch W=2u L=0.5u
M122b out122 inn122 tail122 vss nch W=2u L=0.5u
M122c x122 x122 vdd vdd pch W=4u L=0.5u
M122d out122 x122 vdd vdd pch W=4u L=0.5u
M122t tail122 vbias vss vss nch W=4u L=1u
M123a x123 inp123 tail123 vss nch W=2u L=0.5u
M123b out123 inn123 tail123 vss nch W=2u L=0.5u
M123c x123 x123 vdd vdd pch W=4u L=0.5u
M123d out123 x123 vdd vdd pch W=4u L=0.5u
M123t tail123 vbias vss vss nch W=4u L=1u
M124a x124 inp124 tail124 vss nch W=2u L=0.5u
M124b out124 inn124 tail124 vss nch W=2u L=0.5u
M124c x124 x124 vdd vdd pch W=4u L=0.5u
M124d out124 x124 vdd vdd pch W=4u L=0.5u
M124t tail124 vbias vss vss nch W=4u L=1u
M125a x125 inp125 tail125 vss nch W=2u L=0.5u
M125b out125 inn125 tail125 vss nch W=2u L=0.5u
M125c x125 x125 vdd vdd pch W=4u L=0.5u
M125d out125 x125 vdd vdd pch W=4u L=0.5u
M125t tail125 vbias vss vss nch W=4u L=1u
M126a x126 inp126 tail126 vss nch W=2u L=0.5u
M126b out126 inn126 tail126 vss nch W=2u L=0.5u
M126c x126 x126 vdd vdd pch W=4u L=0.5u
M126d out126 x126 vdd vdd pch W=4u L=0.5u
M126t tail126 vbias vss vss nch W=4u L=1u
M127a x127 inp127 tail127 vss nch W=2u L=0.5u
M127b out127 inn127 tail127 vss nch W=2u L=0.5u
M127c x127 x127 vdd vdd pch W=4u L=0.5u
M127d out127 x127 vdd vdd pch W=4u L=0.5u
M127t tail127 vbias vss vss nch W=4u L=1u
M128a x128 inp128 tail128 vss nch W=2u L=0.5u
M128b out128 inn128 tail128 vss nch W=2u L=0.5u
M128c x128 x128 vdd vdd pch W=4u L=0.5u
M128d out128 x128 vdd vdd pch W=4u L=0.5u
M128t tail128 vbias vss vss nch W=4u L=1u
M129a x129 inp129 tail129 vss nch W=2u L=0.5u
M129b out129 inn129 tail129 vss nch W=2u L=0.5u
M129c x129 x129 vdd vdd pch W=4u L=0.5u
M129d out129 x129 vdd vdd pch W=4u L=0.5u
M129t tail129 vbias vss vss nch W=4u L=1u
M130a x130 inp130 tail130 vss nch W=2u L=0.5u
M130b out130 inn130 tail130 vss nch W=2u L=0.5u
M130c x130 x130 vdd vdd pch W=4u L=0.5u
M130d out130 x130 vdd vdd pch W=4u L=0.5u
M130t tail130 vbias vss vss nch W=4u L=1u
M131a x131 inp131 tail131 vss nch W=2u L=0.5u
M131b out131 inn131 tail131 vss nch W=2u L=0.5u
M131c x131 x131 vdd vdd pch W=4u L=0.5u
M131d out131 x131 vdd vdd pch W=4u L=0.5u
M131t tail131 vbias vss vss nch W=4u L=1u
M132a x132 inp132 tail132 vss nch W=2u L=0.5u
M132b out132 inn132 tail132 vss nch W=2u L=0.5u
M132c x132 x132 vdd vdd pch W=4u L=0.5u
M132d out132 x132 vdd vdd pch W=4u L=0.5u
M132t tail132 vbias vss vss nch W=4u L=1u
M133a x133 inp133 tail133 vss nch W=2u L=0.5u
M133b out133 inn133 tail133 vss nch W=2u L=0.5u
M133c x133 x133 vdd vdd pch W=4u L=0.5u
M133d out133 x133 vdd vdd pch W=4u L=0.5u
M133t tail133 vbias vss vss nch W=4u L=1u
M134a x134 inp134 tail134 vss nch W=2u L=0.5u
M134b out134 inn134 tail134 vss nch W=2u L=0.5u
M134c x134 x134 vdd vdd pch W=4u L=0.5u
M134d out134 x134 vdd vdd pch W=4u L=0.5u
M134t tail134 vbias vss vss nch W=4u L=1u
M135a x135 inp135 tail135 vss nch W=2u L=0.5u
M135b out135 inn135 tail135 vss nch W=2u L=0.5u
M135c x135 x135 vdd vdd pch W=4u L=0.5u
M135d out135 x135 vdd vdd pch W=4u L=0.5u
M135t tail135 vbias vss vss nch W=4u L=1u
M136a x136 inp136 tail136 vss nch W=2u L=0.5u
M136b out136 inn136 tail136 vss nch W=2u L=0.5u
M136c x136 x136 vdd vdd pch W=4u L=0.5u
M136d out136 x136 vdd vdd pch W=4u L=0.5u
M136t tail136 vbias vss vss nch W=4u L=1u
M137a x137 inp137 tail137 vss nch W=2u L=0.5u
M137b out137 inn137 tail137 vss nch W=2u L=0.5u
M137c x137 x137 vdd vdd pch W=4u L=0.5u
M137d out137 x137 vdd vdd pch W=4u L=0.5u
M137t tail137 vbias vss vss nch W=4u L=1u
M138a x138 inp138 tail138 vss nch W=2u L=0.5u
M138b out138 inn138 tail138 vss nch W=2u L=0.5u
M138c x138 x138 vdd vdd pch W=4u L=0.5u
M138d out138 x138 vdd vdd pch W=4u L=0.5u
M138t tail138 vbias vss vss nch W=4u L=1u
M139a x139 inp139 tail139 vss nch W=2u L=0.5u
M139b out139 inn139 tail139 vss nch W=2u L=0.5u
M139c x139 x139 vdd vdd pch W=4u L=0.5u
M139d out139 x139 vdd vdd pch W=4u L=0.5u
M139t tail139 vbias vss vss nch W=4u L=1u
M140a x140 inp140 tail140 vss nch W=2u L=0.5u
M140b out140 inn140 tail140 vss nch W=2u L=0.5u
M140c x140 x140 vdd vdd pch W=4u L=0.5u
M140d out140 x140 vdd vdd pch W=4u L=0.5u
M140t tail140 vbias vss vss nch W=4u L=1u
M141a x141 inp141 tail141 vss nch W=2u L=0.5u
M141b out141 inn141 tail141 vss nch W=2u L=0.5u
M141c x141 x141 vdd vdd pch W=4u L=0.5u
M141d out141 x141 vdd vdd pch W=4u L=0.5u
M141t tail141 vbias vss vss nch W=4u L=1u
M142a x142 inp142 tail142 vss nch W=2u L=0.5u
M142b out142 inn142 tail142 vss nch W=2u L=0.5u
M142c x142 x142 vdd vdd pch W=4u L=0.5u
M142d out142 x142 vdd vdd pch W=4u L=0.5u
M142t tail142 vbias vss vss nch W=4u L=1u
M143a x143 inp143 tail143 vss nch W=2u L=0.5u
M143b out143 inn143 tail143 vss nch W=2u L=0.5u
M143c x143 x143 vdd vdd pch W=4u L=0.5u
M143d out143 x143 vdd vdd pch W=4u L=0.5u
M143t tail143 vbias vss vss nch W=4u L=1u
M144a x144 inp144 tail144 vss nch W=2u L=0.5u
M144b out144 inn144 tail144 vss nch W=2u L=0.5u
M144c x144 x144 vdd vdd pch W=4u L=0.5u
M144d out144 x144 vdd vdd pch W=4u L=0.5u
M144t tail144 vbias vss vss nch W=4u L=1u
M145a x145 inp145 tail145 vss nch W=2u L=0.5u
M145b out145 inn145 tail145 vss nch W=2u L=0.5u
M145c x145 x145 vdd vdd pch W=4u L=0.5u
M145d out145 x145 vdd vdd pch W=4u L=0.5u
M145t tail145 vbias vss vss nch W=4u L=1u
M146a x146 inp146 tail146 vss nch W=2u L=0.5u
M146b out146 inn146 tail146 vss nch W=2u L=0.5u
M146c x146 x146 vdd vdd pch W=4u L=0.5u
M146d out146 x146 vdd vdd pch W=4u L=0.5u
M146t tail146 vbias vss vss nch W=4u L=1u
M147a x147 inp147 tail147 vss nch W=2u L=0.5u
M147b out147 inn147 tail147 vss nch W=2u L=0.5u
M147c x147 x147 vdd vdd pch W=4u L=0.5u
M147d out147 x147 vdd vdd pch W=4u L=0.5u
M147t tail147 vbias vss vss nch W=4u L=1u
M148a x148 inp148 tail148 vss nch W=2u L=0.5u
M148b out148 inn148 tail148 vss nch W=2u L=0.5u
M148c x148 x148 vdd vdd pch W=4u L=0.5u
M148d out148 x148 vdd vdd pch W=4u L=0.5u
M148t tail148 vbias vss vss nch W=4u L=1u
M149a x149 inp149 tail149 vss nch W=2u L=0.5u
M149b out149 inn149 tail149 vss nch W=2u L=0.5u
M149c x149 x149 vdd vdd pch W=4u L=0.5u
M149d out149 x149 vdd vdd pch W=4u L=0.5u
M149t tail149 vbias vss vss nch W=4u L=1u
M150a x150 inp150 tail150 vss nch W=2u L=0.5u
M150b out150 inn150 tail150 vss nch W=2u L=0.5u
M150c x150 x150 vdd vdd pch W=4u L=0.5u
M150d out150 x150 vdd vdd pch W=4u L=0.5u
M150t tail150 vbias vss vss nch W=4u L=1u
M151a x151 inp151 tail151 vss nch W=2u L=0.5u
M151b out151 inn151 tail151 vss nch W=2u L=0.5u
M151c x151 x151 vdd vdd pch W=4u L=0.5u
M151d out151 x151 vdd vdd pch W=4u L=0.5u
M151t tail151 vbias vss vss nch W=4u L=1u
M152a x152 inp152 tail152 vss nch W=2u L=0.5u
M152b out152 inn152 tail152 vss nch W=2u L=0.5u
M152c x152 x152 vdd vdd pch W=4u L=0.5u
M152d out152 x152 vdd vdd pch W=4u L=0.5u
M152t tail152 vbias vss vss nch W=4u L=1u
M153a x153 inp153 tail153 vss nch W=2u L=0.5u
M153b out153 inn153 tail153 vss nch W=2u L=0.5u
M153c x153 x153 vdd vdd pch W=4u L=0.5u
M153d out153 x153 vdd vdd pch W=4u L=0.5u
M153t tail153 vbias vss vss nch W=4u L=1u
M154a x154 inp154 tail154 vss nch W=2u L=0.5u
M154b out154 inn154 tail154 vss nch W=2u L=0.5u
M154c x154 x154 vdd vdd pch W=4u L=0.5u
M154d out154 x154 vdd vdd pch W=4u L=0.5u
M154t tail154 vbias vss vss nch W=4u L=1u
M155a x155 inp155 tail155 vss nch W=2u L=0.5u
M155b out155 inn155 tail155 vss nch W=2u L=0.5u
M155c x155 x155 vdd vdd pch W=4u L=0.5u
M155d out155 x155 vdd vdd pch W=4u L=0.5u
M155t tail155 vbias vss vss nch W=4u L=1u
M156a x156 inp156 tail156 vss nch W=2u L=0.5u
M156b out156 inn156 tail156 vss nch W=2u L=0.5u
M156c x156 x156 vdd vdd pch W=4u L=0.5u
M156d out156 x156 vdd vdd pch W=4u L=0.5u
M156t tail156 vbias vss vss nch W=4u L=1u
M157a x157 inp157 tail157 vss nch W=2u L=0.5u
M157b out157 inn157 tail157 vss nch W=2u L=0.5u
M157c x157 x157 vdd vdd pch W=4u L=0.5u
M157d out157 x157 vdd vdd pch W=4u L=0.5u
M157t tail157 vbias vss vss nch W=4u L=1u
M158a x158 inp158 tail158 vss nch W=2u L=0.5u
M158b out158 inn158 tail158 vss nch W=2u L=0.5u
M158c x158 x158 vdd vdd pch W=4u L=0.5u
M158d out158 x158 vdd vdd pch W=4u L=0.5u
M158t tail158 vbias vss vss nch W=4u L=1u
M159a x159 inp159 tail159 vss nch W=2u L=0.5u
M159b out159 inn159 tail159 vss nch W=2u L=0.5u
M159c x159 x159 vdd vdd pch W=4u L=0.5u
M159d out159 x159 vdd vdd pch W=4u L=0.5u
M159t tail159 vbias vss vss nch W=4u L=1u
M160a x160 inp160 tail160 vss nch W=2u L=0.5u
M160b out160 inn160 tail160 vss nch W=2u L=0.5u
M160c x160 x160 vdd vdd pch W=4u L=0.5u
M160d out160 x160 vdd vdd pch W=4u L=0.5u
M160t tail160 vbias vss vss nch W=4u L=1u
M161a x161 inp161 tail161 vss nch W=2u L=0.5u
M161b out161 inn161 tail161 vss nch W=2u L=0.5u
M161c x161 x161 vdd vdd pch W=4u L=0.5u
M161d out161 x161 vdd vdd pch W=4u L=0.5u
M161t tail161 vbias vss vss nch W=4u L=1u
M162a x162 inp162 tail162 vss nch W=2u L=0.5u
M162b out162 inn162 tail162 vss nch W=2u L=0.5u
M162c x162 x162 vdd vdd pch W=4u L=0.5u
M162d out162 x162 vdd vdd pch W=4u L=0.5u
M162t tail162 vbias vss vss nch W=4u L=1u
M163a x163 inp163 tail163 vss nch W=2u L=0.5u
M163b out163 inn163 tail163 vss nch W=2u L=0.5u
M163c x163 x163 vdd vdd pch W=4u L=0.5u
M163d out163 x163 vdd vdd pch W=4u L=0.5u
M163t tail163 vbias vss vss nch W=4u L=1u
M164a x164 inp164 tail164 vss nch W=2u L=0.5u
M164b out164 inn164 tail164 vss nch W=2u L=0.5u
M164c x164 x164 vdd vdd pch W=4u L=0.5u
M164d out164 x164 vdd vdd pch W=4u L=0.5u
M164t tail164 vbias vss vss nch W=4u L=1u
M165a x165 inp165 tail165 vss nch W=2u L=0.5u
M165b out165 inn165 tail165 vss nch W=2u L=0.5u
M165c x165 x165 vdd vdd pch W=4u L=0.5u
M165d out165 x165 vdd vdd pch W=4u L=0.5u
M165t tail165 vbias vss vss nch W=4u L=1u
M166a x166 inp166 tail166 vss nch W=2u L=0.5u
M166b out166 inn166 tail166 vss nch W=2u L=0.5u
M166c x166 x166 vdd vdd pch W=4u L=0.5u
M166d out166 x166 vdd vdd pch W=4u L=0.5u
M166t tail166 vbias vss vss nch W=4u L=1u
M167a x167 inp167 tail167 vss nch W=2u L=0.5u
M167b out167 inn167 tail167 vss nch W=2u L=0.5u
M167c x167 x167 vdd vdd pch W=4u L=0.5u
M167d out167 x167 vdd vdd pch W=4u L=0.5u
M167t tail167 vbias vss vss nch W=4u L=1u
M168a x168 inp168 tail168 vss nch W=2u L=0.5u
M168b out168 inn168 tail168 vss nch W=2u L=0.5u
M168c x168 x168 vdd vdd pch W=4u L=0.5u
M168d out168 x168 vdd vdd pch W=4u L=0.5u
M168t tail168 vbias vss vss nch W=4u L=1u
M169a x169 inp169 tail169 vss nch W=2u L=0.5u
M169b out169 inn169 tail169 vss nch W=2u L=0.5u
M169c x169 x169 vdd vdd pch W=4u L=0.5u
M169d out169 x169 vdd vdd pch W=4u L=0.5u
M169t tail169 vbias vss vss nch W=4u L=1u
M170a x170 inp170 tail170 vss nch W=2u L=0.5u
M170b out170 inn170 tail170 vss nch W=2u L=0.5u
M170c x170 x170 vdd vdd pch W=4u L=0.5u
M170d out170 x170 vdd vdd pch W=4u L=0.5u
M170t tail170 vbias vss vss nch W=4u L=1u
M171a x171 inp171 tail171 vss nch W=2u L=0.5u
M171b out171 inn171 tail171 vss nch W=2u L=0.5u
M171c x171 x171 vdd vdd pch W=4u L=0.5u
M171d out171 x171 vdd vdd pch W=4u L=0.5u
M171t tail171 vbias vss vss nch W=4u L=1u
M172a x172 inp172 tail172 vss nch W=2u L=0.5u
M172b out172 inn172 tail172 vss nch W=2u L=0.5u
M172c x172 x172 vdd vdd pch W=4u L=0.5u
M172d out172 x172 vdd vdd pch W=4u L=0.5u
M172t tail172 vbias vss vss nch W=4u L=1u
M173a x173 inp173 tail173 vss nch W=2u L=0.5u
M173b out173 inn173 tail173 vss nch W=2u L=0.5u
M173c x173 x173 vdd vdd pch W=4u L=0.5u
M173d out173 x173 vdd vdd pch W=4u L=0.5u
M173t tail173 vbias vss vss nch W=4u L=1u
M174a x174 inp174 tail174 vss nch W=2u L=0.5u
M174b out174 inn174 tail174 vss nch W=2u L=0.5u
M174c x174 x174 vdd vdd pch W=4u L=0.5u
M174d out174 x174 vdd vdd pch W=4u L=0.5u
M174t tail174 vbias vss vss nch W=4u L=1u
M175a x175 inp175 tail175 vss nch W=2u L=0.5u
M175b out175 inn175 tail175 vss nch W=2u L=0.5u
M175c x175 x175 vdd vdd pch W=4u L=0.5u
M175d out175 x175 vdd vdd pch W=4u L=0.5u
M175t tail175 vbias vss vss nch W=4u L=1u
M176a x176 inp176 tail176 vss nch W=2u L=0.5u
M176b out176 inn176 tail176 vss nch W=2u L=0.5u
M176c x176 x176 vdd vdd pch W=4u L=0.5u
M176d out176 x176 vdd vdd pch W=4u L=0.5u
M176t tail176 vbias vss vss nch W=4u L=1u
M177a x177 inp177 tail177 vss nch W=2u L=0.5u
M177b out177 inn177 tail177 vss nch W=2u L=0.5u
M177c x177 x177 vdd vdd pch W=4u L=0.5u
M177d out177 x177 vdd vdd pch W=4u L=0.5u
M177t tail177 vbias vss vss nch W=4u L=1u
M178a x178 inp178 tail178 vss nch W=2u L=0.5u
M178b out178 inn178 tail178 vss nch W=2u L=0.5u
M178c x178 x178 vdd vdd pch W=4u L=0.5u
M178d out178 x178 vdd vdd pch W=4u L=0.5u
M178t tail178 vbias vss vss nch W=4u L=1u
M179a x179 inp179 tail179 vss nch W=2u L=0.5u
M179b out179 inn179 tail179 vss nch W=2u L=0.5u
M179c x179 x179 vdd vdd pch W=4u L=0.5u
M179d out179 x179 vdd vdd pch W=4u L=0.5u
M179t tail179 vbias vss vss nch W=4u L=1u
M180a x180 inp180 tail180 vss nch W=2u L=0.5u
M180b out180 inn180 tail180 vss nch W=2u L=0.5u
M180c x180 x180 vdd vdd pch W=4u L=0.5u
M180d out180 x180 vdd vdd pch W=4u L=0.5u
M180t tail180 vbias vss vss nch W=4u L=1u
M181a x181 inp181 tail181 vss nch W=2u L=0.5u
M181b out181 inn181 tail181 vss nch W=2u L=0.5u
M181c x181 x181 vdd vdd pch W=4u L=0.5u
M181d out181 x181 vdd vdd pch W=4u L=0.5u
M181t tail181 vbias vss vss nch W=4u L=1u
M182a x182 inp182 tail182 vss nch W=2u L=0.5u
M182b out182 inn182 tail182 vss nch W=2u L=0.5u
M182c x182 x182 vdd vdd pch W=4u L=0.5u
M182d out182 x182 vdd vdd pch W=4u L=0.5u
M182t tail182 vbias vss vss nch W=4u L=1u
M183a x183 inp183 tail183 vss nch W=2u L=0.5u
M183b out183 inn183 tail183 vss nch W=2u L=0.5u
M183c x183 x183 vdd vdd pch W=4u L=0.5u
M183d out183 x183 vdd vdd pch W=4u L=0.5u
M183t tail183 vbias vss vss nch W=4u L=1u
M184a x184 inp184 tail184 vss nch W=2u L=0.5u
M184b out184 inn184 tail184 vss nch W=2u L=0.5u
M184c x184 x184 vdd vdd pch W=4u L=0.5u
M184d out184 x184 vdd vdd pch W=4u L=0.5u
M184t tail184 vbias vss vss nch W=4u L=1u
M185a x185 inp185 tail185 vss nch W=2u L=0.5u
M185b out185 inn185 tail185 vss nch W=2u L=0.5u
M185c x185 x185 vdd vdd pch W=4u L=0.5u
M185d out185 x185 vdd vdd pch W=4u L=0.5u
M185t tail185 vbias vss vss nch W=4u L=1u
M186a x186 inp186 tail186 vss nch W=2u L=0.5u
M186b out186 inn186 tail186 vss nch W=2u L=0.5u
M186c x186 x186 vdd vdd pch W=4u L=0.5u
M186d out186 x186 vdd vdd pch W=4u L=0.5u
M186t tail186 vbias vss vss nch W=4u L=1u
M187a x187 inp187 tail187 vss nch W=2u L=0.5u
M187b out187 inn187 tail187 vss nch W=2u L=0.5u
M187c x187 x187 vdd vdd pch W=4u L=0.5u
M187d out187 x187 vdd vdd pch W=4u L=0.5u
M187t tail187 vbias vss vss nch W=4u L=1u
M188a x188 inp188 tail188 vss nch W=2u L=0.5u
M188b out188 inn188 tail188 vss nch W=2u L=0.5u
M188c x188 x188 vdd vdd pch W=4u L=0.5u
M188d out188 x188 vdd vdd pch W=4u L=0.5u
M188t tail188 vbias vss vss nch W=4u L=1u
M189a x189 inp189 tail189 vss nch W=2u L=0.5u
M189b out189 inn189 tail189 vss nch W=2u L=0.5u
M189c x189 x189 vdd vdd pch W=4u L=0.5u
M189d out189 x189 vdd vdd pch W=4u L=0.5u
M189t tail189 vbias vss vss nch W=4u L=1u
M190a x190 inp190 tail190 vss nch W=2u L=0.5u
M190b out190 inn190 tail190 vss nch W=2u L=0.5u
M190c x190 x190 vdd vdd pch W=4u L=0.5u
M190d out190 x190 vdd vdd pch W=4u L=0.5u
M190t tail190 vbias vss vss nch W=4u L=1u
M191a x191 inp191 tail191 vss nch W=2u L=0.5u
M191b out191 inn191 tail191 vss nch W=2u L=0.5u
M191c x191 x191 vdd vdd pch W=4u L=0.5u
M191d out191 x191 vdd vdd pch W=4u L=0.5u
M191t tail191 vbias vss vss nch W=4u L=1u
M192a x192 inp192 tail192 vss nch W=2u L=0.5u
M192b out192 inn192 tail192 vss nch W=2u L=0.5u
M192c x192 x192 vdd vdd pch W=4u L=0.5u
M192d out192 x192 vdd vdd pch W=4u L=0.5u
M192t tail192 vbias vss vss nch W=4u L=1u
M193a x193 inp193 tail193 vss nch W=2u L=0.5u
M193b out193 inn193 tail193 vss nch W=2u L=0.5u
M193c x193 x193 vdd vdd pch W=4u L=0.5u
M193d out193 x193 vdd vdd pch W=4u L=0.5u
M193t tail193 vbias vss vss nch W=4u L=1u
M194a x194 inp194 tail194 vss nch W=2u L=0.5u
M194b out194 inn194 tail194 vss nch W=2u L=0.5u
M194c x194 x194 vdd vdd pch W=4u L=0.5u
M194d out194 x194 vdd vdd pch W=4u L=0.5u
M194t tail194 vbias vss vss nch W=4u L=1u
M195a x195 inp195 tail195 vss nch W=2u L=0.5u
M195b out195 inn195 tail195 vss nch W=2u L=0.5u
M195c x195 x195 vdd vdd pch W=4u L=0.5u
M195d out195 x195 vdd vdd pch W=4u L=0.5u
M195t tail195 vbias vss vss nch W=4u L=1u
M196a x196 inp196 tail196 vss nch W=2u L=0.5u
M196b out196 inn196 tail196 vss nch W=2u L=0.5u
M196c x196 x196 vdd vdd pch W=4u L=0.5u
M196d out196 x196 vdd vdd pch W=4u L=0.5u
M196t tail196 vbias vss vss nch W=4u L=1u
M197a x197 inp197 tail197 vss nch W=2u L=0.5u
M197b out197 inn197 tail197 vss nch W=2u L=0.5u
M197c x197 x197 vdd vdd pch W=4u L=0.5u
M197d out197 x197 vdd vdd pch W=4u L=0.5u
M197t tail197 vbias vss vss nch W=4u L=1u
M198a x198 inp198 tail198 vss nch W=2u L=0.5u
M198b out198 inn198 tail198 vss nch W=2u L=0.5u
M198c x198 x198 vdd vdd pch W=4u L=0.5u
M198d out198 x198 vdd vdd pch W=4u L=0.5u
M198t tail198 vbias vss vss nch W=4u L=1u
M199a x199 inp199 tail199 vss nch W=2u L=0.5u
M199b out199 inn199 tail199 vss nch W=2u L=0.5u
M199c x199 x199 vdd vdd pch W=4u L=0.5u
M199d out199 x199 vdd vdd pch W=4u L=0.5u
M199t tail199 vbias vss vss nch W=4u L=1u
M200a x200 inp200 tail200 vss nch W=2u L=0.5u
M200b out200 inn200 tail200 vss nch W=2u L=0.5u
M200c x200 x200 vdd vdd pch W=4u L=0.5u
M200d out200 x200 vdd vdd pch W=4u L=0.5u
M200t tail200 vbias vss vss nch W=4u L=1u
M201a x201 inp201 tail201 vss nch W=2u L=0.5u
M201b out201 inn201 tail201 vss nch W=2u L=0.5u
M201c x201 x201 vdd vdd pch W=4u L=0.5u
M201d out201 x201 vdd vdd pch W=4u L=0.5u
M201t tail201 vbias vss vss nch W=4u L=1u
M202a x202 inp202 tail202 vss nch W=2u L=0.5u
M202b out202 inn202 tail202 vss nch W=2u L=0.5u
M202c x202 x202 vdd vdd pch W=4u L=0.5u
M202d out202 x202 vdd vdd pch W=4u L=0.5u
M202t tail202 vbias vss vss nch W=4u L=1u
M203a x203 inp203 tail203 vss nch W=2u L=0.5u
M203b out203 inn203 tail203 vss nch W=2u L=0.5u
M203c x203 x203 vdd vdd pch W=4u L=0.5u
M203d out203 x203 vdd vdd pch W=4u L=0.5u
M203t tail203 vbias vss vss nch W=4u L=1u
M204a x204 inp204 tail204 vss nch W=2u L=0.5u
M204b out204 inn204 tail204 vss nch W=2u L=0.5u
M204c x204 x204 vdd vdd pch W=4u L=0.5u
M204d out204 x204 vdd vdd pch W=4u L=0.5u
M204t tail204 vbias vss vss nch W=4u L=1u
M205a x205 inp205 tail205 vss nch W=2u L=0.5u
M205b out205 inn205 tail205 vss nch W=2u L=0.5u
M205c x205 x205 vdd vdd pch W=4u L=0.5u
M205d out205 x205 vdd vdd pch W=4u L=0.5u
M205t tail205 vbias vss vss nch W=4u L=1u
M206a x206 inp206 tail206 vss nch W=2u L=0.5u
M206b out206 inn206 tail206 vss nch W=2u L=0.5u
M206c x206 x206 vdd vdd pch W=4u L=0.5u
M206d out206 x206 vdd vdd pch W=4u L=0.5u
M206t tail206 vbias vss vss nch W=4u L=1u
M207a x207 inp207 tail207 vss nch W=2u L=0.5u
M207b out207 inn207 tail207 vss nch W=2u L=0.5u
M207c x207 x207 vdd vdd pch W=4u L=0.5u
M207d out207 x207 vdd vdd pch W=4u L=0.5u
M207t tail207 vbias vss vss nch W=4u L=1u
M208a x208 inp208 tail208 vss nch W=2u L=0.5u
M208b out208 inn208 tail208 vss nch W=2u L=0.5u
M208c x208 x208 vdd vdd pch W=4u L=0.5u
M208d out208 x208 vdd vdd pch W=4u L=0.5u
M208t tail208 vbias vss vss nch W=4u L=1u
M209a x209 inp209 tail209 vss nch W=2u L=0.5u
M209b out209 inn209 tail209 vss nch W=2u L=0.5u
M209c x209 x209 vdd vdd pch W=4u L=0.5u
M209d out209 x209 vdd vdd pch W=4u L=0.5u
M209t tail209 vbias vss vss nch W=4u L=1u
M210a x210 inp210 tail210 vss nch W=2u L=0.5u
M210b out210 inn210 tail210 vss nch W=2u L=0.5u
M210c x210 x210 vdd vdd pch W=4u L=0.5u
M210d out210 x210 vdd vdd pch W=4u L=0.5u
M210t tail210 vbias vss vss nch W=4u L=1u
M211a x211 inp211 tail211 vss nch W=2u L=0.5u
M211b out211 inn211 tail211 vss nch W=2u L=0.5u
M211c x211 x211 vdd vdd pch W=4u L=0.5u
M211d out211 x211 vdd vdd pch W=4u L=0.5u
M211t tail211 vbias vss vss nch W=4u L=1u
M212a x212 inp212 tail212 vss nch W=2u L=0.5u
M212b out212 inn212 tail212 vss nch W=2u L=0.5u
M212c x212 x212 vdd vdd pch W=4u L=0.5u
M212d out212 x212 vdd vdd pch W=4u L=0.5u
M212t tail212 vbias vss vss nch W=4u L=1u
M213a x213 inp213 tail213 vss nch W=2u L=0.5u
M213b out213 inn213 tail213 vss nch W=2u L=0.5u
M213c x213 x213 vdd vdd pch W=4u L=0.5u
M213d out213 x213 vdd vdd pch W=4u L=0.5u
M213t tail213 vbias vss vss nch W=4u L=1u
M214a x214 inp214 tail214 vss nch W=2u L=0.5u
M214b out214 inn214 tail214 vss nch W=2u L=0.5u
M214c x214 x214 vdd vdd pch W=4u L=0.5u
M214d out214 x214 vdd vdd pch W=4u L=0.5u
M214t tail214 vbias vss vss nch W=4u L=1u
M215a x215 inp215 tail215 vss nch W=2u L=0.5u
M215b out215 inn215 tail215 vss nch W=2u L=0.5u
M215c x215 x215 vdd vdd pch W=4u L=0.5u
M215d out215 x215 vdd vdd pch W=4u L=0.5u
M215t tail215 vbias vss vss nch W=4u L=1u
M216a x216 inp216 tail216 vss nch W=2u L=0.5u
M216b out216 inn216 tail216 vss nch W=2u L=0.5u
M216c x216 x216 vdd vdd pch W=4u L=0.5u
M216d out216 x216 vdd vdd pch W=4u L=0.5u
M216t tail216 vbias vss vss nch W=4u L=1u
M217a x217 inp217 tail217 vss nch W=2u L=0.5u
M217b out217 inn217 tail217 vss nch W=2u L=0.5u
M217c x217 x217 vdd vdd pch W=4u L=0.5u
M217d out217 x217 vdd vdd pch W=4u L=0.5u
M217t tail217 vbias vss vss nch W=4u L=1u
M218a x218 inp218 tail218 vss nch W=2u L=0.5u
M218b out218 inn218 tail218 vss nch W=2u L=0.5u
M218c x218 x218 vdd vdd pch W=4u L=0.5u
M218d out218 x218 vdd vdd pch W=4u L=0.5u
M218t tail218 vbias vss vss nch W=4u L=1u
M219a x219 inp219 tail219 vss nch W=2u L=0.5u
M219b out219 inn219 tail219 vss nch W=2u L=0.5u
M219c x219 x219 vdd vdd pch W=4u L=0.5u
M219d out219 x219 vdd vdd pch W=4u L=0.5u
M219t tail219 vbias vss vss nch W=4u L=1u
M220a x220 inp220 tail220 vss nch W=2u L=0.5u
M220b out220 inn220 tail220 vss nch W=2u L=0.5u
M220c x220 x220 vdd vdd pch W=4u L=0.5u
M220d out220 x220 vdd vdd pch W=4u L=0.5u
M220t tail220 vbias vss vss nch W=4u L=1u
M221a x221 inp221 tail221 vss nch W=2u L=0.5u
M221b out221 inn221 tail221 vss nch W=2u L=0.5u
M221c x221 x221 vdd vdd pch W=4u L=0.5u
M221d out221 x221 vdd vdd pch W=4u L=0.5u
M221t tail221 vbias vss vss nch W=4u L=1u
M222a x222 inp222 tail222 vss nch W=2u L=0.5u
M222b out222 inn222 tail222 vss nch W=2u L=0.5u
M222c x222 x222 vdd vdd pch W=4u L=0.5u
M222d out222 x222 vdd vdd pch W=4u L=0.5u
M222t tail222 vbias vss vss nch W=4u L=1u
M223a x223 inp223 tail223 vss nch W=2u L=0.5u
M223b out223 inn223 tail223 vss nch W=2u L=0.5u
M223c x223 x223 vdd vdd pch W=4u L=0.5u
M223d out223 x223 vdd vdd pch W=4u L=0.5u
M223t tail223 vbias vss vss nch W=4u L=1u
M224a x224 inp224 tail224 vss nch W=2u L=0.5u
M224b out224 inn224 tail224 vss nch W=2u L=0.5u
M224c x224 x224 vdd vdd pch W=4u L=0.5u
M224d out224 x224 vdd vdd pch W=4u L=0.5u
M224t tail224 vbias vss vss nch W=4u L=1u
M225a x225 inp225 tail225 vss nch W=2u L=0.5u
M225b out225 inn225 tail225 vss nch W=2u L=0.5u
M225c x225 x225 vdd vdd pch W=4u L=0.5u
M225d out225 x225 vdd vdd pch W=4u L=0.5u
M225t tail225 vbias vss vss nch W=4u L=1u
M226a x226 inp226 tail226 vss nch W=2u L=0.5u
M226b out226 inn226 tail226 vss nch W=2u L=0.5u
M226c x226 x226 vdd vdd pch W=4u L=0.5u
M226d out226 x226 vdd vdd pch W=4u L=0.5u
M226t tail226 vbias vss vss nch W=4u L=1u
M227a x227 inp227 tail227 vss nch W=2u L=0.5u
M227b out227 inn227 tail227 vss nch W=2u L=0.5u
M227c x227 x227 vdd vdd pch W=4u L=0.5u
M227d out227 x227 vdd vdd pch W=4u L=0.5u
M227t tail227 vbias vss vss nch W=4u L=1u
M228a x228 inp228 tail228 vss nch W=2u L=0.5u
M228b out228 inn228 tail228 vss nch W=2u L=0.5u
M228c x228 x228 vdd vdd pch W=4u L=0.5u
M228d out228 x228 vdd vdd pch W=4u L=0.5u
M228t tail228 vbias vss vss nch W=4u L=1u
M229a x229 inp229 tail229 vss nch W=2u L=0.5u
M229b out229 inn229 tail229 vss nch W=2u L=0.5u
M229c x229 x229 vdd vdd pch W=4u L=0.5u
M229d out229 x229 vdd vdd pch W=4u L=0.5u
M229t tail229 vbias vss vss nch W=4u L=1u
M230a x230 inp230 tail230 vss nch W=2u L=0.5u
M230b out230 inn230 tail230 vss nch W=2u L=0.5u
M230c x230 x230 vdd vdd pch W=4u L=0.5u
M230d out230 x230 vdd vdd pch W=4u L=0.5u
M230t tail230 vbias vss vss nch W=4u L=1u
M231a x231 inp231 tail231 vss nch W=2u L=0.5u
M231b out231 inn231 tail231 vss nch W=2u L=0.5u
M231c x231 x231 vdd vdd pch W=4u L=0.5u
M231d out231 x231 vdd vdd pch W=4u L=0.5u
M231t tail231 vbias vss vss nch W=4u L=1u
M232a x232 inp232 tail232 vss nch W=2u L=0.5u
M232b out232 inn232 tail232 vss nch W=2u L=0.5u
M232c x232 x232 vdd vdd pch W=4u L=0.5u
M232d out232 x232 vdd vdd pch W=4u L=0.5u
M232t tail232 vbias vss vss nch W=4u L=1u
M233a x233 inp233 tail233 vss nch W=2u L=0.5u
M233b out233 inn233 tail233 vss nch W=2u L=0.5u
M233c x233 x233 vdd vdd pch W=4u L=0.5u
M233d out233 x233 vdd vdd pch W=4u L=0.5u
M233t tail233 vbias vss vss nch W=4u L=1u
M234a x234 inp234 tail234 vss nch W=2u L=0.5u
M234b out234 inn234 tail234 vss nch W=2u L=0.5u
M234c x234 x234 vdd vdd pch W=4u L=0.5u
M234d out234 x234 vdd vdd pch W=4u L=0.5u
M234t tail234 vbias vss vss nch W=4u L=1u
M235a x235 inp235 tail235 vss nch W=2u L=0.5u
M235b out235 inn235 tail235 vss nch W=2u L=0.5u
M235c x235 x235 vdd vdd pch W=4u L=0.5u
M235d out235 x235 vdd vdd pch W=4u L=0.5u
M235t tail235 vbias vss vss nch W=4u L=1u
M236a x236 inp236 tail236 vss nch W=2u L=0.5u
M236b out236 inn236 tail236 vss nch W=2u L=0.5u
M236c x236 x236 vdd vdd pch W=4u L=0.5u
M236d out236 x236 vdd vdd pch W=4u L=0.5u
M236t tail236 vbias vss vss nch W=4u L=1u
M237a x237 inp237 tail237 vss nch W=2u L=0.5u
M237b out237 inn237 tail237 vss nch W=2u L=0.5u
M237c x237 x237 vdd vdd pch W=4u L=0.5u
M237d out237 x237 vdd vdd pch W=4u L=0.5u
M237t tail237 vbias vss vss nch W=4u L=1u
M238a x238 inp238 tail238 vss nch W=2u L=0.5u
M238b out238 inn238 tail238 vss nch W=2u L=0.5u
M238c x238 x238 vdd vdd pch W=4u L=0.5u
M238d out238 x238 vdd vdd pch W=4u L=0.5u
M238t tail238 vbias vss vss nch W=4u L=1u
M239a x239 inp239 tail239 vss nch W=2u L=0.5u
M239b out239 inn239 tail239 vss nch W=2u L=0.5u
M239c x239 x239 vdd vdd pch W=4u L=0.5u
M239d out239 x239 vdd vdd pch W=4u L=0.5u
M239t tail239 vbias vss vss nch W=4u L=1u
M240a x240 inp240 tail240 vss nch W=2u L=0.5u
M240b out240 inn240 tail240 vss nch W=2u L=0.5u
M240c x240 x240 vdd vdd pch W=4u L=0.5u
M240d out240 x240 vdd vdd pch W=4u L=0.5u
M240t tail240 vbias vss vss nch W=4u L=1u
M241a x241 inp241 tail241 vss nch W=2u L=0.5u
M241b out241 inn241 tail241 vss nch W=2u L=0.5u
M241c x241 x241 vdd vdd pch W=4u L=0.5u
M241d out241 x241 vdd vdd pch W=4u L=0.5u
M241t tail241 vbias vss vss nch W=4u L=1u
M242a x242 inp242 tail242 vss nch W=2u L=0.5u
M242b out242 inn242 tail242 vss nch W=2u L=0.5u
M242c x242 x242 vdd vdd pch W=4u L=0.5u
M242d out242 x242 vdd vdd pch W=4u L=0.5u
M242t tail242 vbias vss vss nch W=4u L=1u
M243a x243 inp243 tail243 vss nch W=2u L=0.5u
M243b out243 inn243 tail243 vss nch W=2u L=0.5u
M243c x243 x243 vdd vdd pch W=4u L=0.5u
M243d out243 x243 vdd vdd pch W=4u L=0.5u
M243t tail243 vbias vss vss nch W=4u L=1u
M244a x244 inp244 tail244 vss nch W=2u L=0.5u
M244b out244 inn244 tail244 vss nch W=2u L=0.5u
M244c x244 x244 vdd vdd pch W=4u L=0.5u
M244d out244 x244 vdd vdd pch W=4u L=0.5u
M244t tail244 vbias vss vss nch W=4u L=1u
M245a x245 inp245 tail245 vss nch W=2u L=0.5u
M245b out245 inn245 tail245 vss nch W=2u L=0.5u
M245c x245 x245 vdd vdd pch W=4u L=0.5u
M245d out245 x245 vdd vdd pch W=4u L=0.5u
M245t tail245 vbias vss vss nch W=4u L=1u
M246a x246 inp246 tail246 vss nch W=2u L=0.5u
M246b out246 inn246 tail246 vss nch W=2u L=0.5u
M246c x246 x246 vdd vdd pch W=4u L=0.5u
M246d out246 x246 vdd vdd pch W=4u L=0.5u
M246t tail246 vbias vss vss nch W=4u L=1u
M247a x247 inp247 tail247 vss nch W=2u L=0.5u
M247b out247 inn247 tail247 vss nch W=2u L=0.5u
M247c x247 x247 vdd vdd pch W=4u L=0.5u
M247d out247 x247 vdd vdd pch W=4u L=0.5u
M247t tail247 vbias vss vss nch W=4u L=1u
M248a x248 inp248 tail248 vss nch W=2u L=0.5u
M248b out248 inn248 tail248 vss nch W=2u L=0.5u
M248c x248 x248 vdd vdd pch W=4u L=0.5u
M248d out248 x248 vdd vdd pch W=4u L=0.5u
M248t tail248 vbias vss vss nch W=4u L=1u
M249a x249 inp249 tail249 vss nch W=2u L=0.5u
M249b out249 inn249 tail249 vss nch W=2u L=0.5u
M249c x249 x249 vdd vdd pch W=4u L=0.5u
M249d out249 x249 vdd vdd pch W=4u L=0.5u
M249t tail249 vbias vss vss nch W=4u L=1u
M250a x250 inp250 tail250 vss nch W=2u L=0.5u
M250b out250 inn250 tail250 vss nch W=2u L=0.5u
M250c x250 x250 vdd vdd pch W=4u L=0.5u
M250d out250 x250 vdd vdd pch W=4u L=0.5u
M250t tail250 vbias vss vss nch W=4u L=1u
M251a x251 inp251 tail251 vss nch W=2u L=0.5u
M251b out251 inn251 tail251 vss nch W=2u L=0.5u
M251c x251 x251 vdd vdd pch W=4u L=0.5u
M251d out251 x251 vdd vdd pch W=4u L=0.5u
M251t tail251 vbias vss vss nch W=4u L=1u
M252a x252 inp252 tail252 vss nch W=2u L=0.5u
M252b out252 inn252 tail252 vss nch W=2u L=0.5u
M252c x252 x252 vdd vdd pch W=4u L=0.5u
M252d out252 x252 vdd vdd pch W=4u L=0.5u
M252t tail252 vbias vss vss nch W=4u L=1u
M253a x253 inp253 tail253 vss nch W=2u L=0.5u
M253b out253 inn253 tail253 vss nch W=2u L=0.5u
M253c x253 x253 vdd vdd pch W=4u L=0.5u
M253d out253 x253 vdd vdd pch W=4u L=0.5u
M253t tail253 vbias vss vss nch W=4u L=1u
M254a x254 inp254 tail254 vss nch W=2u L=0.5u
M254b out254 inn254 tail254 vss nch W=2u L=0.5u
M254c x254 x254 vdd vdd pch W=4u L=0.5u
M254d out254 x254 vdd vdd pch W=4u L=0.5u
M254t tail254 vbias vss vss nch W=4u L=1u
M255a x255 inp255 tail255 vss nch W=2u L=0.5u
M255b out255 inn255 tail255 vss nch W=2u L=0.5u
M255c x255 x255 vdd vdd pch W=4u L=0.5u
M255d out255 x255 vdd vdd pch W=4u L=0.5u
M255t tail255 vbias vss vss nch W=4u L=1u
* @RNL {
*   # @SELECT-INSTANCE(model="nch") => @SET-SYMBOL $NMOS;
*   # @SELECT-INSTANCE(model="pch") => @SET-SYMBOL $PMOS;
*   &vdd @ADD-TO $SUPPLY_NET_SET;
*   &vss @ADD-TO $GROUND_NET_SET;
*   %g0 = {#M0a #M0b #M0c #M0d #M0t} @GROUP;
*   %dp0 = #M0a(in_p) #M0b(in_n) #M0t(tail) @AS $DIFFERENTIAL_PAIR;
*   %cm0 = #M0c(ref) #M0d(out) @AS $CURRENT_MIRROR;
*   %axis0 = (_, _);
*   #M0a(a) #M0b(b) %axis0(axis) @AS $MIRRORED;
*   #M0c(a) #M0d(b) %axis0(axis) @AS $MIRRORED;
*   #M0t {#M0a #M0b} @DISTANCE("bottom-to-top", min=2);
*   {#M0a #M0b} {#M0c #M0d} @DISTANCE("bottom-to-top", min=2);
*   %g1 = {#M1a #M1b #M1c #M1d #M1t} @GROUP;
*   %dp1 = #M1a(in_p) #M1b(in_n) #M1t(tail) @AS $DIFFERENTIAL_PAIR;
*   %cm1 = #M1c(ref) #M1d(out) @AS $CURRENT_MIRROR;
*   %axis1 = (_, _);
*   #M1a(a) #M1b(b) %axis1(axis) @AS $MIRRORED;
*   #M1c(a) #M1d(b) %axis1(axis) @AS $MIRRORED;
*   #M1t {#M1a #M1b} @DISTANCE("bottom-to-top", min=2);
*   {#M1a #M1b} {#M1c #M1d} @DISTANCE("bottom-to-top", min=2);
*   %g2 = {#M2a #M2b #M2c #M2d #M2t} @GROUP;
*   %dp2 = #M2a(in_p) #M2b(in_n) #M2t(tail) @AS $DIFFERENTIAL_PAIR;
*   %cm2 = #M2c(ref) #M2d(out) @AS $CURRENT_MIRROR;
*   %axis2 = (_, _);
*   #M2a(a) #M2b(b) %axis2(axis) @AS $MIRRORED;
*   #M2c(a) #M2d(b) %axis2(axis) @AS $MIRRORED;
*   #M2t {#M2a #M2b} @DISTANCE("bottom-to-top", min=2);
*   {#M2a #M2b} {#M2c #M2d} @DISTANCE("bottom-to-top", min=2);
*   %g3 = {#M3a #M3b #M3c #M3d #M3t} @GROUP;
*   %dp3 = #M3a(in_p) #M3b(in_n) #M3t(tail) @AS $DIFFERENTIAL_PAIR;
*   %cm3 = #M3c(ref) #M3d(out) @AS $CURRENT_MIRROR;
*   %axis3 = (_, _);
*   #M3a(a) #M3b(b) %axis3(axis) @AS $MIRRORED;
*   #M3c(a) #M3d(b) %axis3(axis) @AS $MIRRORED;
*   #M3t {#M3a #M3b} @DISTANCE("bottom-to-top", min=2);
*   {#M3a #M3b} {#M3c #M3d} @DISTANCE("bottom-to-top", min=2);
*   %g4 = {#M4a #M4b #M4c #M4d #M4t} @GROUP;
*   %dp4 = #M4a(in_p) #M4b(in_n) #M4t(tail) @AS $DIFFERENTIAL_PAIR;
*   %cm4 = #M4c(ref) #M4d(out) @AS $CURRENT_MIRROR;
*   %axis4 = (_, _);
*   #M4a(a) #M4b(b) %axis4(axis) @AS $MIRRORED;
*   #M4c(a) #M4d(b) %axis4(axis) @AS $MIRRORED;
*   #M4t {#M4a #M4b} @DISTANCE("bottom-to-top", min=2);
*   {#M4a #M4b} {#M4c #M4d} @DISTANCE("bottom-to-top", min=2);
*   %g5 = {#M5a #M5b #M5c #M5d #M5t} @GROUP;
*   %dp5 = #M5a(in_p) #M5b(in_n) #M5t(tail) @AS $DIFFERENTIAL_PAIR;
*   %cm5 = #M5c(ref) #M5d(out) @AS $CURRENT_MIRROR;
*   %axis5 = (_, _);
*   #M5a(a) #M5b(b) %axis5(axis) @AS $MIRRORED;
*   #M5c(a) #M5d(b) %axis5(axis) @AS $MIRRORED;
*   #M5t {#M5a #M5b} @DISTANCE("bottom-to-top", min=2);
*   {#M5a #M5b} {#M5c #M5d} @DISTANCE("bottom-to-top", min=2);
*   %g6 = {#M6a #M6b #M6c #M6d #M6t} @GROUP;
*   %dp6 = #M6a(in_p) #M6b(in_n) #M6t(tail) @AS $DIFFERENTIAL_PAIR;
*   %cm6 = #M6c(ref) #M6d(out) @AS $CURRENT_MIRROR;
*   %axis6 = (_, _);
*   #M6a(a) #M6b(b) %axis6(axis) @AS $MIRRORED;
*   #M6c(a) #M6d(b) %axis6(axis) @AS $MIRRORED;
*   #M6t {#M6a #M6b} @DISTANCE("bottom-to-top", min=2);
*   {#M6a #M6b} {#M6c #M6d} @DISTANCE("bottom-to-top", min=2);
*   %g7 = {#M7a #M7b #M7c #M7d #M7t} @GROUP;
*   %dp7 = #M7a(in_p) #M7b(in_n) #M7t(tail) @AS $DIFFERENTIAL_PAIR;
*   %cm7 = #M7c(ref) #M7d(out) @AS $CURRENT_MIRROR;
*   %axis7 = (_, _);
*   #M7a(a) #M7b(b) %axis7(axis) @AS $MIRRORED;
*   #M7c(a) #M7d(b) %axis7(axis) @AS $MIRRORED;
*   #M7t {#M7a #M7b} @DISTANCE("bottom-to-top", min=2);
*   {#M7a #M7b} {#M7c #M7d} @DISTANCE("bottom-to-top", min=2);
*   %g8 = {#M8a #M8b #M8c #M8d #M8t} @GROUP;
*   %dp8 = #M8a(in_p) #M8b(in_n) #M8t(tail) @AS $DIFFERENTIAL_PAIR;
*   %cm8 = #M8c(ref) #M8d(out) @AS $CURRENT_MIRROR;
*   %axis8 = (_, _);
*   #M8a(a) #M8b(b) %axis8(axis) @AS $MIRRORED;
*   #M8c(a) #M8d(b) %axis8(axis) @AS $MIRRORED;
*   #M8t {#M8a #M8b} @DISTANCE("bottom-to-top", min=2);
*   {#M8a #M8b} {#M8c #M8d} @DISTANCE("bottom-to-top", min=2);
*   %g9 = {#M9a #M9b #M9c #M9d #M9t} @GROUP;
*   %dp9 = #M9a(in_p) #M9b(in_n) #M9t(tail) @AS $DIFFERENTIAL_PAIR;
*   %cm9 = #M9c(ref) #M9d(out) @AS $CURRENT_MIRROR;
*   %axis9 = (_, _);
*   #M9a(a) #M9b(b) %axis9(axis) @AS $MIRRORED;
*   #M9c(a) #M9d(b) %axis9(axis) @AS $MIRRORED;
*   #M9t {#M9a #M9b} @DISTANCE("bottom-to-top", min=2);
*   {#M9a #M9b} {#M9c #M9d} @DISTANCE("bottom-to-top", min=2);
*   %g10 = {#M10a #M10b #M10c #M10d #M10t} @GROUP;
*   %dp10 = #M10a(in_p) #M10b(in_n) #M10t(tail) @AS $DIFFERENTIAL_PAIR;
*   %cm10 = #M10c(ref) #M10d(out) @AS $CURRENT_MIRROR;
*   %axis10 = (_, _);
*   #M10a(a) #M10b(b) %axis10(axis) @AS $MIRRORED;
*   #M10c(a) #M10d(b) %axis10(axis) @AS $MIRRORED;
*   #M10t {#M10a #M10b} @DISTANCE("bottom-to-top", min=2);
*   {#M10a #M10b} {#M10c #M10d} @DISTANCE("bottom-to-top", min=2);
*   %g11 = {#M11a #M11b #M11c #M11d #M11t} @GROUP;
*   %dp11 = #M11a(in_p) #M11b(in_n) #M11t(tail) @AS $DIFFERENTIAL_PAIR;
*   %cm11 = #M11c(ref) #M11d(out) @AS $CURRENT_MIRROR;
*   %axis11 = (_, _);
*   #M11a(a) #M11b(b) %axis11(axis) @AS $MIRRORED;
*   #M11c(a) #M11d(b) %axis11(axis) @AS $MIRRORED;
*   #M11t {#M11a #M11b} @DISTANCE("bottom-to-top", min=2);
*   {#M11a #M11b} {#M11c #M11d} @DISTANCE("bottom-to-top", min=2);
*   %g12 = {#M12a #M12b #M12c #M12d #M12t} @GROUP;
*   %dp12 = #M12a(in_p) #M12b(in_n) #M12t(tail) @AS $DIFFERENTIAL_PAIR;
*   %cm12 = #M12c(ref) #M12d(out) @AS $CURRENT_MIRROR;
*   %axis12 = (_, _);
*   #M12a(a) #M12b(b) %axis12(axis) @AS $MIRRORED;
*   #M12c(a) #M12d(b) %axis12(axis) @AS $MIRRORED;
*   #M12t {#M12a #M12b} @DISTANCE("bottom-to-top", min=2);
*   {#M12a #M12b} {#M12c #M12d} @DISTANCE("bottom-to-top", min=2);
*   %g13 = {#M13a #M13b #M13c #M13d #M13t} @GROUP;
*   %dp13 = #M13a(in_p) #M13b(in_n) #M13t(tail) @AS $DIFFERENTIAL_PAIR;
*   %cm13 = #M13c(ref) #M13d(out) @AS $CURRENT_MIRROR;
*   %axis13 = (_, _);
*   #M13a(a) #M13b(b) %axis13(axis) @AS $MIRRORED;
*   #M13c(a) #M13d(b) %axis13(axis) @AS $MIRRORED;
*   #M13t {#M13a #M13b} @DISTANCE("bottom-to-top", min=2);
*   {#M13a #M13b} {#M13c #M13d} @DISTANCE("bottom-to-top", min=2);
*   %g14 = {#M14a #M14b #M14c #M14d #M14t} @GROUP;
*   %dp14 = #M14a(in_p) #M14b(in_n) #M14t(tail) @AS $DIFFERENTIAL_PAIR;
*   %cm14 = #M14c(ref) #M14d(out) @AS $CURRENT_MIRROR;
*   %axis14 = (_, _);
*   #M14a(a) #M14b(b) %axis14(axis) @AS $MIRRORED;
*   #M14c(a) #M14d(b) %axis14(axis) @AS $MIRRORED;
*   #M14t {#M14a #M14b} @DISTANCE("bottom-to-top", min=2);
*   {#M14a #M14b} {#M14c #M14d} @DISTANCE("bottom-to-top", min=2);
*   %g15 = {#M15a #M15b #M15c #M15d #M15t} @GROUP;
*   %dp15 = #M15a(in_p) #M15b(in_n) #M15t(tail) @AS $DIFFERENTIAL_PAIR;
*   %cm15 = #M15c(ref) #M15d(out) @AS $CURRENT_MIRROR;
*   %axis15 = (_, _);
*   #M15a(a) #M15b(b) %axis15(axis) @AS $MIRRORED;
*   #M15c(a) #M15d(b) %axis15(axis) @AS $MIRRORED;
*   #M15t {#M15a #M15b} @DISTANCE("bottom-to-top", min=2);
*   {#M15a #M15b} {#M15c #M15d} @DISTANCE("bottom-to-top", min=2);
*   %g16 = {#M16a #M16b #M16c #M16d #M16t} @GROUP;
*   %dp16 = #M16a(in_p) #M16b(in_n) #M16t(tail) @AS $DIFFERENTIAL_PAIR;
*   %cm16 = #M16c(ref) #M16d(out) @AS $CURRENT_MIRROR;
*   %axis16 = (_, _);
*   #M16a(a) #M16b(b) %axis16(axis) @AS $MIRRORED;
*   #M16c(a) #M16d(b) %axis16(axis) @AS $MIRRORED;
*   #M16t {#M16a #M16b} @DISTANCE("bottom-to-top", min=2);
*   {#M16a #M16b} {#M16c #M16d} @DISTANCE("bottom-to-top", min=2);
*   %g17 = {#M17a #M17b #M17c #M17d #M17t} @GROUP;
*   %dp17 = #M17a(in_p) #M17b(in_n) #M17t(tail) @AS $DIFFERENTIAL_PAIR;
*   %cm17 = #M17c(ref) #M17d(out) @AS $CURRENT_MIRROR;
*   %axis17 = (_, _);
*   #M17a(a) #M17b(b) %axis17(axis) @AS $MIRRORED;
*   #M17c(a) #M17d(b) %axis17(axis) @AS $MIRRORED;
*   #M17t {#M17a #M17b} @DISTANCE("bottom-to-top", min=2);
*   {#M17a #M17b} {#M17c #M17d} @DISTANCE("bottom-to-top", min=2);
*   %g18 = {#M18a #M18b #M18c #M18d #M18t} @GROUP;
*   %dp18 = #M18a(in_p) #M18b(in_n) #M18t(tail) @AS $DIFFERENTIAL_PAIR;
*   %cm18 = #M18c(ref) #M18d(out) @AS $CURRENT_MIRROR;
*   %axis18 = (_, _);
*   #M18a(a) #M18b(b) %axis18(axis) @AS $MIRRORED;
*   #M18c(a) #M18d(b) %axis18(axis) @AS $MIRRORED;
*   #M18t {#M18a #M18b} @DISTANCE("bottom-to-top", min=2);
*   {#M18a #M18b} {#M18c #M18d} @DISTANCE("bottom-to-top", min=2);
*   %g19 = {#M19a #M19b #M19c #M19d #M19t} @GROUP;
*   %dp19 = #M19a(in_p) #M19b(in_n) #M19t(tail) @AS $DIFFERENTIAL_PAIR;
*   %cm19 = #M19c(ref) #M19d(out) @AS $CURRENT_MIRROR;
*   %axis19 = (_, _);
*   #M19a(a) #M19b(b) %axis19(axis) @AS $MIRRORED;
*   #M19c(a) #M19d(b) %axis19(axis) @AS $MIRRORED;
*   #M19t {#M19a #M19b} @DISTANCE("bottom-to-top", min=2);
*   {#M19a #M19b} {#M19c #M19d} @DISTANCE("bottom-to-top", min=2);
*   %g20 = {#M20a #M20b #M20c #M20d #M20t} @GROUP;
*   %dp20 = #M20a(in_p) #M20b(in_n) #M20t(tail) @AS $DIFFERENTIAL_PAIR;
*   %cm20 = #M20c(ref) #M20d(out) @AS $CURRENT_MIRROR;
*   %axis20 = (_, _);
*   #M20a(a) #M20b(b) %axis20(axis) @AS $MIRRORED;
*   #M20c(a) #M20d(b) %axis20(axis) @AS $MIRRORED;
*   #M20t {#M20a #M20b} @DISTANCE("bottom-to-top", min=2);
*   {#M20a #M20b} {#M20c #M20d} @DISTANCE("bottom-to-top", min=2);
*   %g21 = {#M21a #M21b #M21c #M21d #M21t} @GROUP;
*   %dp21 = #M21a(in_p) #M21b(in_n) #M21t(tail) @AS $DIFFERENTIAL_PAIR;
*   %cm21 = #M21c(ref) #M21d(out) @AS $CURRENT_MIRROR;
*   %axis21 = (_, _);
*   #M21a(a) #M21b(b) %axis21(axis) @AS $MIRRORED;
*   #M21c(a) #M21d(b) %axis21(axis) @AS $MIRRORED;
*   #M21t {#M21a #M21b} @DISTANCE("bottom-to-top", min=2);
*   {#M21a #M21b} {#M21c #M21d} @DISTANCE("bottom-to-top", min=2);
*   %g22 = {#M22a #M22b #M22c #M22d #M22t} @GROUP;
*   %dp22 = #M22a(in_p) #M22b(in_n) #M22t(tail) @AS $DIFFERENTIAL_PAIR;
*   %cm22 = #M22c(ref) #M22d(out) @AS $CURRENT_MIRROR;
*   %axis22 = (_, _);
*   #M22a(a) #M22b(b) %axis22(axis) @AS $MIRRORED;
*   #M22c(a) #M22d(b) %axis22(axis) @AS $MIRRORED;
*   #M22t {#M22a #M22b} @DISTANCE("bottom-to-top", min=2);
*   {#M22a #M22b} {#M22c #M22d} @DISTANCE("bottom-to-top", min=2);
*   %g23 = {#M23a #M23b #M23c #M23d #M23t} @GROUP;
*   %dp23 = #M23a(in_p) #M23b(in_n) #M23t(tail) @AS $DIFFERENTIAL_PAIR;
*   %cm23 = #M23c(ref) #M23d(out) @AS $CURRENT_MIRROR;
*   %axis23 = (_, _);
*   #M23a(a) #M23b(b) %axis23(axis) @AS $MIRRORED;
*   #M23c(a) #M23d(b) %axis23(axis) @AS $MIRRORED;
*   #M23t {#M23a #M23b} @DISTANCE("bottom-to-top", min=2);
*   {#M23a #M23b} {#M23c #M23d} @DISTANCE("bottom-to-top", min=2);
*   %g24 = {#M24a #M24b #M24c #M24d #M24t} @GROUP;
*   %dp24 = #M24a(in_p) #M24b(in_n) #M24t(tail) @AS $DIFFERENTIAL_PAIR;
*   %cm24 = #M24c(ref) #M24d(out) @AS $CURRENT_MIRROR;
*   %axis24 = (_, _);
*   #M24a(a) #M24b(b) %axis24(axis) @AS $MIRRORED;
*   #M24c(a) #M24d(b) %axis24(axis) @AS $MIRRORED;
*   #M24t {#M24a #M24b} @DISTANCE("bottom-to-top", min=2);
*   {#M24a #M24b} {#M24c #M24d} @DISTANCE("bottom-to-top", min=2);
*   %g25 = {#M25a #M25b #M25c #M25d #M25t} @GROUP;
*   %dp25 = #M25a(in_p) #M25b(in_n) #M25t(tail) @AS $DIFFERENTIAL_PAIR;
*   %cm25 = #M25c(ref) #M25d(out) @AS $CURRENT_MIRROR;
*   %axis25 = (_, _);
*   #M25a(a) #M25b(b) %axis25(axis) @AS $MIRRORED;
*   #M25c(a) #M25d(b) %axis25(axis) @AS $MIRRORED;
*   #M25t {#M25a #M25b} @DISTANCE("bottom-to-top", min=2);
*   {#M25a #M25b} {#M25c #M25d} @DISTANCE("bottom-to-top", min=2);
*   %g26 = {#M26a #M26b #M26c #M26d #M26t} @GROUP;
*   %dp26 = #M26a(in_p) #M26b(in_n) #M26t(tail) @AS $DIFFERENTIAL_PAIR;
*   %cm26 = #M26c(ref) #M26d(out) @AS $CURRENT_MIRROR;
*   %axis26 = (_, _);
*   #M26a(a) #M26b(b) %axis26(axis) @AS $MIRRORED;
*   #M26c(a) #M26d(b) %axis26(axis) @AS $MIRRORED;
*   #M26t {#M26a #M26b} @DISTANCE("bottom-to-top", min=2);
*   {#M26a #M26b} {#M26c #M26d} @DISTANCE("bottom-to-top", min=2);
*   %g27 = {#M27a #M27b #M27c #M27d #M27t} @GROUP;
*   %dp27 = #M27a(in_p) #M27b(in_n) #M27t(tail) @AS $DIFFERENTIAL_PAIR;
*   %cm27 = #M27c(ref) #M27d(out) @AS $CURRENT_MIRROR;
*   %axis27 = (_, _);
*   #M27a(a) #M27b(b) %axis27(axis) @AS $MIRRORED;
*   #M27c(a) #M27d(b) %axis27(axis) @AS $MIRRORED;
*   #M27t {#M27a #M27b} @DISTANCE("bottom-to-top", min=2);
*   {#M27a #M27b} {#M27c #M27d} @DISTANCE("bottom-to-top", min=2);
*   %g28 = {#M28a #M28b #M28c #M28d #M28t} @GROUP;
*   %dp28 = #M28a(in_p) #M28b(in_n) #M28t(tail) @AS $DIFFERENTIAL_PAIR;
*   %cm28 = #M28c(ref) #M28d(out) @AS $CURRENT_MIRROR;
*   %axis28 = (_, _);
*   #M28a(a) #M28b(b) %axis28(axis) @AS $MIRRORED;
*   #M28c(a) #M28d(b) %axis28(axis) @AS $MIRRORED;
*   #M28t {#M28a #M28b} @DISTANCE("bottom-to-top", min=2);
*   {#M28a #M28b} {#M28c #M28d} @DISTANCE("bottom-to-top", min=2);
*   %g29 = {#M29a #M29b #M29c #M29d #M29t} @GROUP;
*   %dp29 = #M29a(in_p) #M29b(in_n) #M29t(tail) @AS $DIFFERENTIAL_PAIR;
*   %cm29 = #M29c(ref) #M29d(out) @AS $CURRENT_MIRROR;
*   %axis29 = (_, _);
*   #M29a(a) #M29b(b) %axis29(axis) @AS $MIRRORED;
*   #M29c(a) #M29d(b) %axis29(axis) @AS $MIRRORED;
*   #M29t {#M29a #M29b} @DISTANCE("bottom-to-top", min=2);
*   {#M29a #M29b} {#M29c #M29d} @DISTANCE("bottom-to-top", min=2);
*   %g30 = {#M30a #M30b #M30c #M30d #M30t} @GROUP;
*   %dp30 = #M30a(in_p) #M30b(in_n) #M30t(tail) @AS $DIFFERENTIAL_PAIR;
*   %cm30 = #M30c(ref) #M30d(out) @AS $CURRENT_MIRROR;
*   %axis30 = (_, _);
*   #M30a(a) #M30b(b) %axis30(axis) @AS $MIRRORED;
*   #M30c(a) #M30d(b) %axis30(axis) @AS $MIRRORED;
*   #M30t {#M30a #M30b} @DISTANCE("bottom-to-top", min=2);
*   {#M30a #M30b} {#M30c #M30d} @DISTANCE("bottom-to-top", min=2);
*   %g31 = {#M31a #M31b #M31c #M31d #M31t} @GROUP;
*   %dp31 = #M31a(in_p) #M31b(in_n) #M31t(tail) @AS $DIFFERENTIAL_PAIR;
*   %cm31 = #M31c(ref) #M31d(out) @AS $CURRENT_MIRROR;
*   %axis31 = (_, _);
*   #M31a(a) #M31b(b) %axis31(axis) @AS $MIRRORED;
*   #M31c(a) #M31d(b) %axis31(axis) @AS $MIRRORED;
*   #M31t {#M31a #M31b} @DISTANCE("bottom-to-top", min=2);
*   {#M31a #M31b} {#M31c #M31d} @DISTANCE("bottom-to-top", min=2);
*   %g32 = {#M32a #M32b #M32c #M32d #M32t} @GROUP;
*   %dp32 = #M32a(in_p) #M32b(in_n) #M32t(tail) @AS $DIFFERENTIAL_PAIR;
*   %cm32 = #M32c(ref) #M32d(out) @AS $CURRENT_MIRROR;
*   %axis32 = (_, _);
*   #M32a(a) #M32b(b) %axis32(axis) @AS $MIRRORED;
*   #M32c(a) #M32d(b) %axis32(axis) @AS $MIRRORED;
*   #M32t {#M32a #M32b} @DISTANCE("bottom-to-top", min=2);
*   {#M32a #M32b} {#M32c #M32d} @DISTANCE("bottom-to-top", min=2);
*   %g33 = {#M33a #M33b #M33c #M33d #M33t} @GROUP;
*   %dp33 = #M33a(in_p) #M33b(in_n) #M33t(tail) @AS $DIFFERENTIAL_PAIR;
*   %cm33 = #M33c(ref) #M33d(out) @AS $CURRENT_MIRROR;
*   %axis33 = (_, _);
*   #M33a(a) #M33b(b) %axis33(axis) @AS $MIRRORED;
*   #M33c(a) #M33d(b) %axis33(axis) @AS $MIRRORED;
*   #M33t {#M33a #M33b} @DISTANCE("bottom-to-top", min=2);
*   {#M33a #M33b} {#M33c #M33d} @DISTANCE("bottom-to-top", min=2);
*   %g34 = {#M34a #M34b #M34c #M34d #M34t} @GROUP;
*   %dp34 = #M34a(in_p) #M34b(in_n) #M34t(tail) @AS $DIFFERENTIAL_PAIR;
*   %cm34 = #M34c(ref) #M34d(out) @AS $CURRENT_MIRROR;
*   %axis34 = (_, _);
*   #M34a(a) #M34b(b) %axis34(axis) @AS $MIRRORED;
*   #M34c(a) #M34d(b) %axis34(axis) @AS $MIRRORED;
*   #M34t {#M34a #M34b} @DISTANCE("bottom-to-top", min=2);
*   {#M34a #M34b} {#M34c #M34d} @DISTANCE("bottom-to-top", min=2);
*   %g35 = {#M35a #M35b #M35c #M35d #M35t} @GROUP;
*   %dp35 = #M35a(in_p) #M35b(in_n) #M35t(tail) @AS $DIFFERENTIAL_PAIR;
*   %cm35 = #M35c(ref) #M35d(out) @AS $CURRENT_MIRROR;
*   %axis35 = (_, _);
*   #M35a(a) #M35b(b) %axis35(axis) @AS $MIRRORED;
*   #M35c(a) #M35d(b) %axis35(axis) @AS $MIRRORED;
*   #M35t {#M35a #M35b} @DISTANCE("bottom-to-top", min=2);
*   {#M35a #M35b} {#M35c #M35d} @DISTANCE("bottom-to-top", min=2);
*   %g36 = {#M36a #M36b #M36c #M36d #M36t} @GROUP;
*   %dp36 = #M36a(in_p) #M36b(in_n) #M36t(tail) @AS $DIFFERENTIAL_PAIR;
*   %cm36 = #M36c(ref) #M36d(out) @AS $CURRENT_MIRROR;
*   %axis36 = (_, _);
*   #M36a(a) #M36b(b) %axis36(axis) @AS $MIRRORED;
*   #M36c(a) #M36d(b) %axis36(axis) @AS $MIRRORED;
*   #M36t {#M36a #M36b} @DISTANCE("bottom-to-top", min=2);
*   {#M36a #M36b} {#M36c #M36d} @DISTANCE("bottom-to-top", min=2);
*   %g37 = {#M37a #M37b #M37c #M37d #M37t} @GROUP;
*   %dp37 = #M37a(in_p) #M37b(in_n) #M37t(tail) @AS $DIFFERENTIAL_PAIR;
*   %cm37 = #M37c(ref) #M37d(out) @AS $CURRENT_MIRROR;
*   %axis37 = (_, _);
*   #M37a(a) #M37b(b) %axis37(axis) @AS $MIRRORED;
*   #M37c(a) #M37d(b) %axis37(axis) @AS $MIRRORED;
*   #M37t {#M37a #M37b} @DISTANCE("bottom-to-top", min=2);
*   {#M37a #M37b} {#M37c #M37d} @DISTANCE("bottom-to-top", min=2);
*   %g38 = {#M38a #M38b #M38c #M38d #M38t} @GROUP;
*   %dp38 = #M38a(in_p) #M38b(in_n) #M38t(tail) @AS $DIFFERENTIAL_PAIR;
*   %cm38 = #M38c(ref) #M38d(out) @AS $CURRENT_MIRROR;
*   %axis38 = (_, _);
*   #M38a(a) #M38b(b) %axis38(axis) @AS $MIRRORED;
*   #M38c(a) #M38d(b) %axis38(axis) @AS $MIRRORED;
*   #M38t {#M38a #M38b} @DISTANCE("bottom-to-top", min=2);
*   {#M38a #M38b} {#M38c #M38d} @DISTANCE("bottom-to-top", min=2);
*   %g39 = {#M39a #M39b #M39c #M39d #M39t} @GROUP;
*   %dp39 = #M39a(in_p) #M39b(in_n) #M39t(tail) @AS $DIFFERENTIAL_PAIR;
*   %cm39 = #M39c(ref) #M39d(out) @AS $CURRENT_MIRROR;
*   %axis39 = (_, _);
*   #M39a(a) #M39b(b) %axis39(axis) @AS $MIRRORED;
*   #M39c(a) #M39d(b) %axis39(axis) @AS $MIRRORED;
*   #M39t {#M39a #M39b} @DISTANCE("bottom-to-top", min=2);
*   {#M39a #M39b} {#M39c #M39d} @DISTANCE("bottom-to-top", min=2);
*   %g40 = {#M40a #M40b #M40c #M40d #M40t} @GROUP;
*   %dp40 = #M40a(in_p) #M40b(in_n) #M40t(tail) @AS $DIFFERENTIAL_PAIR;
*   %cm40 = #M40c(ref) #M40d(out) @AS $CURRENT_MIRROR;
*   %axis40 = (_, _);
*   #M40a(a) #M40b(b) %axis40(axis) @AS $MIRRORED;
*   #M40c(a) #M40d(b) %axis40(axis) @AS $MIRRORED;
*   #M40t {#M40a #M40b} @DISTANCE("bottom-to-top", min=2);
*   {#M40a #M40b} {#M40c #M40d} @DISTANCE("bottom-to-top", min=2);
*   %g41 = {#M41a #M41b #M41c #M41d #M41t} @GROUP;
*   %dp41 = #M41a(in_p) #M41b(in_n) #M41t(tail) @AS $DIFFERENTIAL_PAIR;
*   %cm41 = #M41c(ref) #M41d(out) @AS $CURRENT_MIRROR;
*   %axis41 = (_, _);
*   #M41a(a) #M41b(b) %axis41(axis) @AS $MIRRORED;
*   #M41c(a) #M41d(b) %axis41(axis) @AS $MIRRORED;
*   #M41t {#M41a #M41b} @DISTANCE("bottom-to-top", min=2);
*   {#M41a #M41b} {#M41c #M41d} @DISTANCE("bottom-to-top", min=2);
*   %g42 = {#M42a #M42b #M42c #M42d #M42t} @GROUP;
*   %dp42 = #M42a(in_p) #M42b(in_n) #M42t(tail) @AS $DIFFERENTIAL_PAIR;
*   %cm42 = #M42c(ref) #M42d(out) @AS $CURRENT_MIRROR;
*   %axis42 = (_, _);
*   #M42a(a) #M42b(b) %axis42(axis) @AS $MIRRORED;
*   #M42c(a) #M42d(b) %axis42(axis) @AS $MIRRORED;
*   #M42t {#M42a #M42b} @DISTANCE("bottom-to-top", min=2);
*   {#M42a #M42b} {#M42c #M42d} @DISTANCE("bottom-to-top", min=2);
*   %g43 = {#M43a #M43b #M43c #M43d #M43t} @GROUP;
*   %dp43 = #M43a(in_p) #M43b(in_n) #M43t(tail) @AS $DIFFERENTIAL_PAIR;
*   %cm43 = #M43c(ref) #M43d(out) @AS $CURRENT_MIRROR;
*   %axis43 = (_, _);
*   #M43a(a) #M43b(b) %axis43(axis) @AS $MIRRORED;
*   #M43c(a) #M43d(b) %axis43(axis) @AS $MIRRORED;
*   #M43t {#M43a #M43b} @DISTANCE("bottom-to-top", min=2);
*   {#M43a #M43b} {#M43c #M43d} @DISTANCE("bottom-to-top", min=2);
*   %g44 = {#M44a #M44b #M44c #M44d #M44t} @GROUP;
*   %dp44 = #M44a(in_p) #M44b(in_n) #M44t(tail) @AS $DIFFERENTIAL_PAIR;
*   %cm44 = #M44c(ref) #M44d(out) @AS $CURRENT_MIRROR;
*   %axis44 = (_, _);
*   #M44a(a) #M44b(b) %axis44(axis) @AS $MIRRORED;
*   #M44c(a) #M44d(b) %axis44(axis) @AS $MIRRORED;
*   #M44t {#M44a #M44b} @DISTANCE("bottom-to-top", min=2);
*   {#M44a #M44b} {#M44c #M44d} @DISTANCE("bottom-to-top", min=2);
*   %g45 = {#M45a #M45b #M45c #M45d #M45t} @GROUP;
*   %dp45 = #M45a(in_p) #M45b(in_n) #M45t(tail) @AS $DIFFERENTIAL_PAIR;
*   %cm45 = #M45c(ref) #M45d(out) @AS $CURRENT_MIRROR;
*   %axis45 = (_, _);
*   #M45a(a) #M45b(b) %axis45(axis) @AS $MIRRORED;
*   #M45c(a) #M45d(b) %axis45(axis) @AS $MIRRORED;
*   #M45t {#M45a #M45b} @DISTANCE("bottom-to-top", min=2);
*   {#M45a #M45b} {#M45c #M45d} @DISTANCE("bottom-to-top", min=2);
*   %g46 = {#M46a #M46b #M46c #M46d #M46t} @GROUP;
*   %dp46 = #M46a(in_p) #M46b(in_n) #M46t(tail) @AS $DIFFERENTIAL_PAIR;
*   %cm46 = #M46c(ref) #M46d(out) @AS $CURRENT_MIRROR;
*   %axis46 = (_, _);
*   #M46a(a) #M46b(b) %axis46(axis) @AS $MIRRORED;
*   #M46c(a) #M46d(b) %axis46(axis) @AS $MIRRORED;
*   #M46t {#M46a #M46b} @DISTANCE("bottom-to-top", min=2);
*   {#M46a #M46b} {#M46c #M46d} @DISTANCE("bottom-to-top", min=2);
*   %g47 = {#M47a #M47b #M47c #M47d #M47t} @GROUP;
*   %dp47 = #M47a(in_p) #M47b(in_n) #M47t(tail) @AS $DIFFERENTIAL_PAIR;
*   %cm47 = #M47c(ref) #M47d(out) @AS $CURRENT_MIRROR;
*   %axis47 = (_, _);
*   #M47a(a) #M47b(b) %axis47(axis) @AS $MIRRORED;
*   #M47c(a) #M47d(b) %axis47(axis) @AS $MIRRORED;
*   #M47t {#M47a #M47b} @DISTANCE("bottom-to-top", min=2);
*   {#M47a #M47b} {#M47c #M47d} @DISTANCE("bottom-to-top", min=2);
*   %g48 = {#M48a #M48b #M48c #M48d #M48t} @GROUP;
*   %dp48 = #M48a(in_p) #M48b(in_n) #M48t(tail) @AS $DIFFERENTIAL_PAIR;
*   %cm48 = #M48c(ref) #M48d(out) @AS $CURRENT_MIRROR;
*   %axis48 = (_, _);
*   #M48a(a) #M48b(b) %axis48(axis) @AS $MIRRORED;
*   #M48c(a) #M48d(b) %axis48(axis) @AS $MIRRORED;
*   #M48t {#M48a #M48b} @DISTANCE("bottom-to-top", min=2);
*   {#M48a #M48b} {#M48c #M48d} @DISTANCE("bottom-to-top", min=2);
*   %g49 = {#M49a #M49b #M49c #M49d #M49t} @GROUP;
*   %dp49 = #M49a(in_p) #M49b(in_n) #M49t(tail) @AS $DIFFERENTIAL_PAIR;
*   %cm49 = #M49c(ref) #M49d(out) @AS $CURRENT_MIRROR;
*   %axis49 = (_, _);
*   #M49a(a) #M49b(b) %axis49(axis) @AS $MIRRORED;
*   #M49c(a) #M49d(b) %axis49(axis) @AS $MIRRORED;
*   #M49t {#M49a #M49b} @DISTANCE("bottom-to-top", min=2);
*   {#M49a #M49b} {#M49c #M49d} @DISTANCE("bottom-to-top", min=2);
*   %g50 = {#M50a #M50b #M50c #M50d #M50t} @GROUP;
*   %dp50 = #M50a(in_p) #M50b(in_n) #M50t(tail) @AS $DIFFERENTIAL_PAIR;
*   %cm50 = #M50c(ref) #M50d(out) @AS $CURRENT_MIRROR;
*   %axis50 = (_, _);
*   #M50a(a) #M50b(b) %axis50(axis) @AS $MIRRORED;
*   #M50c(a) #M50d(b) %axis50(axis) @AS $MIRRORED;
*   #M50t {#M50a #M50b} @DISTANCE("bottom-to-top", min=2);
*   {#M50a #M50b} {#M50c #M50d} @DISTANCE("bottom-to-top", min=2);
*   %g51 = {#M51a #M51b #M51c #M51d #M51t} @GROUP;
*   %dp51 = #M51a(in_p) #M51b(in_n) #M51t(tail) @AS $DIFFERENTIAL_PAIR;
*   %cm51 = #M51c(ref) #M51d(out) @AS $CURRENT_MIRROR;
*   %axis51 = (_, _);
*   #M51a(a) #M51b(b) %axis51(axis) @AS $MIRRORED;
*   #M51c(a) #M51d(b) %axis51(axis) @AS $MIRRORED;
*   #M51t {#M51a #M51b} @DISTANCE("bottom-to-top", min=2);
*   {#M51a #M51b} {#M51c #M51d} @DISTANCE("bottom-to-top", min=2);
*   %g52 = {#M52a #M52b #M52c #M52d #M52t} @GROUP;
*   %dp52 = #M52a(in_p) #M52b(in_n) #M52t(tail) @AS $DIFFERENTIAL_PAIR;
*   %cm52 = #M52c(ref) #M52d(out) @AS $CURRENT_MIRROR;
*   %axis52 = (_, _);
*   #M52a(a) #M52b(b) %axis52(axis) @AS $MIRRORED;
*   #M52c(a) #M52d(b) %axis52(axis) @AS $MIRRORED;
*   #M52t {#M52a #M52b} @DISTANCE("bottom-to-top", min=2);
*   {#M52a #M52b} {#M52c #M52d} @DISTANCE("bottom-to-top", min=2);
*   %g53 = {#M53a #M53b #M53c #M53d #M53t} @GROUP;
*   %dp53 = #M53a(in_p) #M53b(in_n) #M53t(tail) @AS $DIFFERENTIAL_PAIR;
*   %cm53 = #M53c(ref) #M53d(out) @AS $CURRENT_MIRROR;
*   %axis53 = (_, _);
*   #M53a(a) #M53b(b) %axis53(axis) @AS $MIRRORED;
*   #M53c(a) #M53d(b) %axis53(axis) @AS $MIRRORED;
*   #M53t {#M53a #M53b} @DISTANCE("bottom-to-top", min=2);
*   {#M53a #M53b} {#M53c #M53d} @DISTANCE("bottom-to-top", min=2);
*   %g54 = {#M54a #M54b #M54c #M54d #M54t} @GROUP;
*   %dp54 = #M54a(in_p) #M54b(in_n) #M54t(tail) @AS $DIFFERENTIAL_PAIR;
*   %cm54 = #M54c(ref) #M54d(out) @AS $CURRENT_MIRROR;
*   %axis54 = (_, _);
*   #M54a(a) #M54b(b) %axis54(axis) @AS $MIRRORED;
*   #M54c(a) #M54d(b) %axis54(axis) @AS $MIRRORED;
*   #M54t {#M54a #M54b} @DISTANCE("bottom-to-top", min=2);
*   {#M54a #M54b} {#M54c #M54d} @DISTANCE("bottom-to-top", min=2);
*   %g55 = {#M55a #M55b #M55c #M55d #M55t} @GROUP;
*   %dp55 = #M55a(in_p) #M55b(in_n) #M55t(tail) @AS $DIFFERENTIAL_PAIR;
*   %cm55 = #M55c(ref) #M55d(out) @AS $CURRENT_MIRROR;
*   %axis55 = (_, _);
*   #M55a(a) #M55b(b) %axis55(axis) @AS $MIRRORED;
*   #M55c(a) #M55d(b) %axis55(axis) @AS $MIRRORED;
*   #M55t {#M55a #M55b} @DISTANCE("bottom-to-top", min=2);
*   {#M55a #M55b} {#M55c #M55d} @DISTANCE("bottom-to-top", min=2);
*   %g56 = {#M56a #M56b #M56c #M56d #M56t} @GROUP;
*   %dp56 = #M56a(in_p) #M56b(in_n) #M56t(tail) @AS $DIFFERENTIAL_PAIR;
*   %cm56 = #M56c(ref) #M56d(out) @AS $CURRENT_MIRROR;
*   %axis56 = (_, _);
*   #M56a(a) #M56b(b) %axis56(axis) @AS $MIRRORED;
*   #M56c(a) #M56d(b) %axis56(axis) @AS $MIRRORED;
*   #M56t {#M56a #M56b} @DISTANCE("bottom-to-top", min=2);
*   {#M56a #M56b} {#M56c #M56d} @DISTANCE("bottom-to-top", min=2);
*   %g57 = {#M57a #M57b #M57c #M57d #M57t} @GROUP;
*   %dp57 = #M57a(in_p) #M57b(in_n) #M57t(tail) @AS $DIFFERENTIAL_PAIR;
*   %cm57 = #M57c(ref) #M57d(out) @AS $CURRENT_MIRROR;
*   %axis57 = (_, _);
*   #M57a(a) #M57b(b) %axis57(axis) @AS $MIRRORED;
*   #M57c(a) #M57d(b) %axis57(axis) @AS $MIRRORED;
*   #M57t {#M57a #M57b} @DISTANCE("bottom-to-top", min=2);
*   {#M57a #M57b} {#M57c #M57d} @DISTANCE("bottom-to-top", min=2);
*   %g58 = {#M58a #M58b #M58c #M58d #M58t} @GROUP;
*   %dp58 = #M58a(in_p) #M58b(in_n) #M58t(tail) @AS $DIFFERENTIAL_PAIR;
*   %cm58 = #M58c(ref) #M58d(out) @AS $CURRENT_MIRROR;
*   %axis58 = (_, _);
*   #M58a(a) #M58b(b) %axis58(axis) @AS $MIRRORED;
*   #M58c(a) #M58d(b) %axis58(axis) @AS $MIRRORED;
*   #M58t {#M58a #M58b} @DISTANCE("bottom-to-top", min=2);
*   {#M58a #M58b} {#M58c #M58d} @DISTANCE("bottom-to-top", min=2);
*   %g59 = {#M59a #M59b #M59c #M59d #M59t} @GROUP;
*   %dp59 = #M59a(in_p) #M59b(in_n) #M59t(tail) @AS $DIFFERENTIAL_PAIR;
*   %cm59 = #M59c(ref) #M59d(out) @AS $CURRENT_MIRROR;
*   %axis59 = (_, _);
*   #M59a(a) #M59b(b) %axis59(axis) @AS $MIRRORED;
*   #M59c(a) #M59d(b) %axis59(axis) @AS $MIRRORED;
*   #M59t {#M59a #M59b} @DISTANCE("bottom-to-top", min=2);
*   {#M59a #M59b} {#M59c #M59d} @DISTANCE("bottom-to-top", min=2);
*   %g60 = {#M60a #M60b #M60c #M60d #M60t} @GROUP;
*   %dp60 = #M60a(in_p) #M60b(in_n) #M60t(tail) @AS $DIFFERENTIAL_PAIR;
*   %cm60 = #M60c(ref) #M60d(out) @AS $CURRENT_MIRROR;
*   %axis60 = (_, _);
*   #M60a(a) #M60b(b) %axis60(axis) @AS $MIRRORED;
*   #M60c(a) #M60d(b) %axis60(axis) @AS $MIRRORED;
*   #M60t {#M60a #M60b} @DISTANCE("bottom-to-top", min=2);
*   {#M60a #M60b} {#M60c #M60d} @DISTANCE("bottom-to-top", min=2);
*   %g61 = {#M61a #M61b #M61c #M61d #M61t} @GROUP;
*   %dp61 = #M61a(in_p) #M61b(in_n) #M61t(tail) @AS $DIFFERENTIAL_PAIR;
*   %cm61 = #M61c(ref) #M61d(out) @AS $CURRENT_MIRROR;
*   %axis61 = (_, _);
*   #M61a(a) #M61b(b) %axis61(axis) @AS $MIRRORED;
*   #M61c(a) #M61d(b) %axis61(axis) @AS $MIRRORED;
*   #M61t {#M61a #M61b} @DISTANCE("bottom-to-top", min=2);
*   {#M61a #M61b} {#M61c #M61d} @DISTANCE("bottom-to-top", min=2);
*   %g62 = {#M62a #M62b #M62c #M62d #M62t} @GROUP;
*   %dp62 = #M62a(in_p) #M62b(in_n) #M62t(tail) @AS $DIFFERENTIAL_PAIR;
*   %cm62 = #M62c(ref) #M62d(out) @AS $CURRENT_MIRROR;
*   %axis62 = (_, _);
*   #M62a(a) #M62b(b) %axis62(axis) @AS $MIRRORED;
*   #M62c(a) #M62d(b) %axis62(axis) @AS $MIRRORED;
*   #M62t {#M62a #M62b} @DISTANCE("bottom-to-top", min=2);
*   {#M62a #M62b} {#M62c #M62d} @DISTANCE("bottom-to-top", min=2);
*   %g63 = {#M63a #M63b #M63c #M63d #M63t} @GROUP;
*   %dp63 = #M63a(in_p) #M63b(in_n) #M63t(tail) @AS $DIFFERENTIAL_PAIR;
*   %cm63 = #M63c(ref) #M63d(out) @AS $CURRENT_MIRROR;
*   %axis63 = (_, _);
*   #M63a(a) #M63b(b) %axis63(axis) @AS $MIRRORED;
*   #M63c(a) #M63d(b) %axis63(axis) @AS $MIRRORED;
*   #M63t {#M63a #M63b} @DISTANCE("bottom-to-top", min=2);
*   {#M63a #M63b} {#M63c #M63d} @DISTANCE("bottom-to-top", min=2);
*   %g64 = {#M64a #M64b #M64c #M64d #M64t} @GROUP;
*   %dp64 = #M64a(in_p) #M64b(in_n) #M64t(tail) @AS $DIFFERENTIAL_PAIR;
*   %cm64 = #M64c(ref) #M64d(out) @AS $CURRENT_MIRROR;
*   %axis64 = (_, _);
*   #M64a(a) #M64b(b) %axis64(axis) @AS $MIRRORED;
*   #M64c(a) #M64d(b) %axis64(axis) @AS $MIRRORED;
*   #M64t {#M64a #M64b} @DISTANCE("bottom-to-top", min=2);
*   {#M64a #M64b} {#M64c #M64d} @DISTANCE("bottom-to-top", min=2);
*   %g65 = {#M65a #M65b #M65c #M65d #M65t} @GROUP;
*   %dp65 = #M65a(in_p) #M65b(in_n) #M65t(tail) @AS $DIFFERENTIAL_PAIR;
*   %cm65 = #M65c(ref) #M65d(out) @AS $CURRENT_MIRROR;
*   %axis65 = (_, _);
*   #M65a(a) #M65b(b) %axis65(axis) @AS $MIRRORED;
*   #M65c(a) #M65d(b) %axis65(axis) @AS $MIRRORED;
*   #M65t {#M65a #M65b} @DISTANCE("bottom-to-top", min=2);
*   {#M65a #M65b} {#M65c #M65d} @DISTANCE("bottom-to-top", min=2);
*   %g66 = {#M66a #M66b #M66c #M66d #M66t} @GROUP;
*   %dp66 = #M66a(in_p) #M66b(in_n) #M66t(tail) @AS $DIFFERENTIAL_PAIR;
*   %cm66 = #M66c(ref) #M66d(out) @AS $CURRENT_MIRROR;
*   %axis66 = (_, _);
*   #M66a(a) #M66b(b) %axis66(axis) @AS $MIRRORED;
*   #M66c(a) #M66d(b) %axis66(axis) @AS $MIRRORED;
*   #M66t {#M66a #M66b} @DISTANCE("bottom-to-top", min=2);
*   {#M66a #M66b} {#M66c #M66d} @DISTANCE("bottom-to-top", min=2);
*   %g67 = {#M67a #M67b #M67c #M67d #M67t} @GROUP;
*   %dp67 = #M67a(in_p) #M67b(in_n) #M67t(tail) @AS $DIFFERENTIAL_PAIR;
*   %cm67 = #M67c(ref) #M67d(out) @AS $CURRENT_MIRROR;
*   %axis67 = (_, _);
*   #M67a(a) #M67b(b) %axis67(axis) @AS $MIRRORED;
*   #M67c(a) #M67d(b) %axis67(axis) @AS $MIRRORED;
*   #M67t {#M67a #M67b} @DISTANCE("bottom-to-top", min=2);
*   {#M67a #M67b} {#M67c #M67d} @DISTANCE("bottom-to-top", min=2);
*   %g68 = {#M68a #M68b #M68c #M68d #M68t} @GROUP;
*   %dp68 = #M68a(in_p) #M68b(in_n) #M68t(tail) @AS $DIFFERENTIAL_PAIR;
*   %cm68 = #M68c(ref) #M68d(out) @AS $CURRENT_MIRROR;
*   %axis68 = (_, _);
*   #M68a(a) #M68b(b) %axis68(axis) @AS $MIRRORED;
*   #M68c(a) #M68d(b) %axis68(axis) @AS $MIRRORED;
*   #M68t {#M68a #M68b} @DISTANCE("bottom-to-top", min=2);
*   {#M68a #M68b} {#M68c #M68d} @DISTANCE("bottom-to-top", min=2);
*   %g69 = {#M69a #M69b #M69c #M69d #M69t} @GROUP;
*   %dp69 = #M69a(in_p) #M69b(in_n) #M69t(tail) @AS $DIFFERENTIAL_PAIR;
*   %cm69 = #M69c(ref) #M69d(out) @AS $CURRENT_MIRROR;
*   %axis69 = (_, _);
*   #M69a(a) #M69b(b) %axis69(axis) @AS $MIRRORED;
*   #M69c(a) #M69d(b) %axis69(axis) @AS $MIRRORED;
*   #M69t {#M69a #M69b} @DISTANCE("bottom-to-top", min=2);
*   {#M69a #M69b} {#M69c #M69d} @DISTANCE("bottom-to-top", min=2);
*   %g70 = {#M70a #M70b #M70c #M70d #M70t} @GROUP;
*   %dp70 = #M70a(in_p) #M70b(in_n) #M70t(tail) @AS $DIFFERENTIAL_PAIR;
*   %cm70 = #M70c(ref) #M70d(out) @AS $CURRENT_MIRROR;
*   %axis70 = (_, _);
*   #M70a(a) #M70b(b) %axis70(axis) @AS $MIRRORED;
*   #M70c(a) #M70d(b) %axis70(axis) @AS $MIRRORED;
*   #M70t {#M70a #M70b} @DISTANCE("bottom-to-top", min=2);
*   {#M70a #M70b} {#M70c #M70d} @DISTANCE("bottom-to-top", min=2);
*   %g71 = {#M71a #M71b #M71c #M71d #M71t} @GROUP;
*   %dp71 = #M71a(in_p) #M71b(in_n) #M71t(tail) @AS $DIFFERENTIAL_PAIR;
*   %cm71 = #M71c(ref) #M71d(out) @AS $CURRENT_MIRROR;
*   %axis71 = (_, _);
*   #M71a(a) #M71b(b) %axis71(axis) @AS $MIRRORED;
*   #M71c(a) #M71d(b) %axis71(axis) @AS $MIRRORED;
*   #M71t {#M71a #M71b} @DISTANCE("bottom-to-top", min=2);
*   {#M71a #M71b} {#M71c #M71d} @DISTANCE("bottom-to-top", min=2);
*   %g72 = {#M72a #M72b #M72c #M72d #M72t} @GROUP;
*   %dp72 = #M72a(in_p) #M72b(in_n) #M72t(tail) @AS $DIFFERENTIAL_PAIR;
*   %cm72 = #M72c(ref) #M72d(out) @AS $CURRENT_MIRROR;
*   %axis72 = (_, _);
*   #M72a(a) #M72b(b) %axis72(axis) @AS $MIRRORED;
*   #M72c(a) #M72d(b) %axis72(axis) @AS $MIRRORED;
*   #M72t {#M72a #M72b} @DISTANCE("bottom-to-top", min=2);
*   {#M72a #M72b} {#M72c #M72d} @DISTANCE("bottom-to-top", min=2);
*   %g73 = {#M73a #M73b #M73c #M73d #M73t} @GROUP;
*   %dp73 = #M73a(in_p) #M73b(in_n) #M73t(tail) @AS $DIFFERENTIAL_PAIR;
*   %cm73 = #M73c(ref) #M73d(out) @AS $CURRENT_MIRROR;
*   %axis73 = (_, _);
*   #M73a(a) #M73b(b) %axis73(axis) @AS $MIRRORED;
*   #M73c(a) #M73d(b) %axis73(axis) @AS $MIRRORED;
*   #M73t {#M73a #M73b} @DISTANCE("bottom-to-top", min=2);
*   {#M73a #M73b} {#M73c #M73d} @DISTANCE("bottom-to-top", min=2);
*   %g74 = {#M74a #M74b #M74c #M74d #M74t} @GROUP;
*   %dp74 = #M74a(in_p) #M74b(in_n) #M74t(tail) @AS $DIFFERENTIAL_PAIR;
*   %cm74 = #M74c(ref) #M74d(out) @AS $CURRENT_MIRROR;
*   %axis74 = (_, _);
*   #M74a(a) #M74b(b) %axis74(axis) @AS $MIRRORED;
*   #M74c(a) #M74d(b) %axis74(axis) @AS $MIRRORED;
*   #M74t {#M74a #M74b} @DISTANCE("bottom-to-top", min=2);
*   {#M74a #M74b} {#M74c #M74d} @DISTANCE("bottom-to-top", min=2);
*   %g75 = {#M75a #M75b #M75c #M75d #M75t} @GROUP;
*   %dp75 = #M75a(in_p) #M75b(in_n) #M75t(tail) @AS $DIFFERENTIAL_PAIR;
*   %cm75 = #M75c(ref) #M75d(out) @AS $CURRENT_MIRROR;
*   %axis75 = (_, _);
*   #M75a(a) #M75b(b) %axis75(axis) @AS $MIRRORED;
*   #M75c(a) #M75d(b) %axis75(axis) @AS $MIRRORED;
*   #M75t {#M75a #M75b} @DISTANCE("bottom-to-top", min=2);
*   {#M75a #M75b} {#M75c #M75d} @DISTANCE("bottom-to-top", min=2);
*   %g76 = {#M76a #M76b #M76c #M76d #M76t} @GROUP;
*   %dp76 = #M76a(in_p) #M76b(in_n) #M76t(tail) @AS $DIFFERENTIAL_PAIR;
*   %cm76 = #M76c(ref) #M76d(out) @AS $CURRENT_MIRROR;
*   %axis76 = (_, _);
*   #M76a(a) #M76b(b) %axis76(axis) @AS $MIRRORED;
*   #M76c(a) #M76d(b) %axis76(axis) @AS $MIRRORED;
*   #M76t {#M76a #M76b} @DISTANCE("bottom-to-top", min=2);
*   {#M76a #M76b} {#M76c #M76d} @DISTANCE("bottom-to-top", min=2);
*   %g77 = {#M77a #M77b #M77c #M77d #M77t} @GROUP;
*   %dp77 = #M77a(in_p) #M77b(in_n) #M77t(tail) @AS $DIFFERENTIAL_PAIR;
*   %cm77 = #M77c(ref) #M77d(out) @AS $CURRENT_MIRROR;
*   %axis77 = (_, _);
*   #M77a(a) #M77b(b) %axis77(axis) @AS $MIRRORED;
*   #M77c(a) #M77d(b) %axis77(axis) @AS $MIRRORED;
*   #M77t {#M77a #M77b} @DISTANCE("bottom-to-top", min=2);
*   {#M77a #M77b} {#M77c #M77d} @DISTANCE("bottom-to-top", min=2);
*   %g78 = {#M78a #M78b #M78c #M78d #M78t} @GROUP;
*   %dp78 = #M78a(in_p) #M78b(in_n) #M78t(tail) @AS $DIFFERENTIAL_PAIR;
*   %cm78 = #M78c(ref) #M78d(out) @AS $CURRENT_MIRROR;
*   %axis78 = (_, _);
*   #M78a(a) #M78b(b) %axis78(axis) @AS $MIRRORED;
*   #M78c(a) #M78d(b) %axis78(axis) @AS $MIRRORED;
*   #M78t {#M78a #M78b} @DISTANCE("bottom-to-top", min=2);
*   {#M78a #M78b} {#M78c #M78d} @DISTANCE("bottom-to-top", min=2);
*   %g79 = {#M79a #M79b #M79c #M79d #M79t} @GROUP;
*   %dp79 = #M79a(in_p) #M79b(in_n) #M79t(tail) @AS $DIFFERENTIAL_PAIR;
*   %cm79 = #M79c(ref) #M79d(out) @AS $CURRENT_MIRROR;
*   %axis79 = (_, _);
*   #M79a(a) #M79b(b) %axis79(axis) @AS $MIRRORED;
*   #M79c(a) #M79d(b) %axis79(axis) @AS $MIRRORED;
*   #M79t {#M79a #M79b} @DISTANCE("bottom-to-top", min=2);
*   {#M79a #M79b} {#M79c #M79d} @DISTANCE("bottom-to-top", min=2);
*   %g80 = {#M80a #M80b #M80c #M80d #M80t} @GROUP;
*   %dp80 = #M80a(in_p) #M80b(in_n) #M80t(tail) @AS $DIFFERENTIAL_PAIR;
*   %cm80 = #M80c(ref) #M80d(out) @AS $CURRENT_MIRROR;
*   %axis80 = (_, _);
*   #M80a(a) #M80b(b) %axis80(axis) @AS $MIRRORED;
*   #M80c(a) #M80d(b) %axis80(axis) @AS $MIRRORED;
*   #M80t {#M80a #M80b} @DISTANCE("bottom-to-top", min=2);
*   {#M80a #M80b} {#M80c #M80d} @DISTANCE("bottom-to-top", min=2);
*   %g81 = {#M81a #M81b #M81c #M81d #M81t} @GROUP;
*   %dp81 = #M81a(in_p) #M81b(in_n) #M81t(tail) @AS $DIFFERENTIAL_PAIR;
*   %cm81 = #M81c(ref) #M81d(out) @AS $CURRENT_MIRROR;
*   %axis81 = (_, _);
*   #M81a(a) #M81b(b) %axis81(axis) @AS $MIRRORED;
*   #M81c(a) #M81d(b) %axis81(axis) @AS $MIRRORED;
*   #M81t {#M81a #M81b} @DISTANCE("bottom-to-top", min=2);
*   {#M81a #M81b} {#M81c #M81d} @DISTANCE("bottom-to-top", min=2);
*   %g82 = {#M82a #M82b #M82c #M82d #M82t} @GROUP;
*   %dp82 = #M82a(in_p) #M82b(in_n) #M82t(tail) @AS $DIFFERENTIAL_PAIR;
*   %cm82 = #M82c(ref) #M82d(out) @AS $CURRENT_MIRROR;
*   %axis82 = (_, _);
*   #M82a(a) #M82b(b) %axis82(axis) @AS $MIRRORED;
*   #M82c(a) #M82d(b) %axis82(axis) @AS $MIRRORED;
*   #M82t {#M82a #M82b} @DISTANCE("bottom-to-top", min=2);
*   {#M82a #M82b} {#M82c #M82d} @DISTANCE("bottom-to-top", min=2);
*   %g83 = {#M83a #M83b #M83c #M83d #M83t} @GROUP;
*   %dp83 = #M83a(in_p) #M83b(in_n) #M83t(tail) @AS $DIFFERENTIAL_PAIR;
*   %cm83 = #M83c(ref) #M83d(out) @AS $CURRENT_MIRROR;
*   %axis83 = (_, _);
*   #M83a(a) #M83b(b) %axis83(axis) @AS $MIRRORED;
*   #M83c(a) #M83d(b) %axis83(axis) @AS $MIRRORED;
*   #M83t {#M83a #M83b} @DISTANCE("bottom-to-top", min=2);
*   {#M83a #M83b} {#M83c #M83d} @DISTANCE("bottom-to-top", min=2);
*   %g84 = {#M84a #M84b #M84c #M84d #M84t} @GROUP;
*   %dp84 = #M84a(in_p) #M84b(in_n) #M84t(tail) @AS $DIFFERENTIAL_PAIR;
*   %cm84 = #M84c(ref) #M84d(out) @AS $CURRENT_MIRROR;
*   %axis84 = (_, _);
*   #M84a(a) #M84b(b) %axis84(axis) @AS $MIRRORED;
*   #M84c(a) #M84d(b) %axis84(axis) @AS $MIRRORED;
*   #M84t {#M84a #M84b} @DISTANCE("bottom-to-top", min=2);
*   {#M84a #M84b} {#M84c #M84d} @DISTANCE("bottom-to-top", min=2);
*   %g85 = {#M85a #M85b #M85c #M85d #M85t} @GROUP;
*   %dp85 = #M85a(in_p) #M85b(in_n) #M85t(tail) @AS $DIFFERENTIAL_PAIR;
*   %cm85 = #M85c(ref) #M85d(out) @AS $CURRENT_MIRROR;
*   %axis85 = (_, _);
*   #M85a(a) #M85b(b) %axis85(axis) @AS $MIRRORED;
*   #M85c(a) #M85d(b) %axis85(axis) @AS $MIRRORED;
*   #M85t {#M85a #M85b} @DISTANCE("bottom-to-top", min=2);
*   {#M85a #M85b} {#M85c #M85d} @DISTANCE("bottom-to-top", min=2);
*   %g86 = {#M86a #M86b #M86c #M86d #M86t} @GROUP;
*   %dp86 = #M86a(in_p) #M86b(in_n) #M86t(tail) @AS $DIFFERENTIAL_PAIR;
*   %cm86 = #M86c(ref) #M86d(out) @AS $CURRENT_MIRROR;
*   %axis86 = (_, _);
*   #M86a(a) #M86b(b) %axis86(axis) @AS $MIRRORED;
*   #M86c(a) #M86d(b) %axis86(axis) @AS $MIRRORED;
*   #M86t {#M86a #M86b} @DISTANCE("bottom-to-top", min=2);
*   {#M86a #M86b} {#M86c #M86d} @DISTANCE("bottom-to-top", min=2);
*   %g87 = {#M87a #M87b #M87c #M87d #M87t} @GROUP;
*   %dp87 = #M87a(in_p) #M87b(in_n) #M87t(tail) @AS $DIFFERENTIAL_PAIR;
*   %cm87 = #M87c(ref) #M87d(out) @AS $CURRENT_MIRROR;
*   %axis87 = (_, _);
*   #M87a(a) #M87b(b) %axis87(axis) @AS $MIRRORED;
*   #M87c(a) #M87d(b) %axis87(axis) @AS $MIRRORED;
*   #M87t {#M87a #M87b} @DISTANCE("bottom-to-top", min=2);
*   {#M87a #M87b} {#M87c #M87d} @DISTANCE("bottom-to-top", min=2);
*   %g88 = {#M88a #M88b #M88c #M88d #M88t} @GROUP;
*   %dp88 = #M88a(in_p) #M88b(in_n) #M88t(tail) @AS $DIFFERENTIAL_PAIR;
*   %cm88 = #M88c(ref) #M88d(out) @AS $CURRENT_MIRROR;
*   %axis88 = (_, _);
*   #M88a(a) #M88b(b) %axis88(axis) @AS $MIRRORED;
*   #M88c(a) #M88d(b) %axis88(axis) @AS $MIRRORED;
*   #M88t {#M88a #M88b} @DISTANCE("bottom-to-top", min=2);
*   {#M88a #M88b} {#M88c #M88d} @DISTANCE("bottom-to-top", min=2);
*   %g89 = {#M89a #M89b #M89c #M89d #M89t} @GROUP;
*   %dp89 = #M89a(in_p) #M89b(in_n) #M89t(tail) @AS $DIFFERENTIAL_PAIR;
*   %cm89 = #M89c(ref) #M89d(out) @AS $CURRENT_MIRROR;
*   %axis89 = (_, _);
*   #M89a(a) #M89b(b) %axis89(axis) @AS $MIRRORED;
*   #M89c(a) #M89d(b) %axis89(axis) @AS $MIRRORED;
*   #M89t {#M89a #M89b} @DISTANCE("bottom-to-top", min=2);
*   {#M89a #M89b} {#M89c #M89d} @DISTANCE("bottom-to-top", min=2);
*   %g90 = {#M90a #M90b #M90c #M90d #M90t} @GROUP;
*   %dp90 = #M90a(in_p) #M90b(in_n) #M90t(tail) @AS $DIFFERENTIAL_PAIR;
*   %cm90 = #M90c(ref) #M90d(out) @AS $CURRENT_MIRROR;
*   %axis90 = (_, _);
*   #M90a(a) #M90b(b) %axis90(axis) @AS $MIRRORED;
*   #M90c(a) #M90d(b) %axis90(axis) @AS $MIRRORED;
*   #M90t {#M90a #M90b} @DISTANCE("bottom-to-top", min=2);
*   {#M90a #M90b} {#M90c #M90d} @DISTANCE("bottom-to-top", min=2);
*   %g91 = {#M91a #M91b #M91c #M91d #M91t} @GROUP;
*   %dp91 = #M91a(in_p) #M91b(in_n) #M91t(tail) @AS $DIFFERENTIAL_PAIR;
*   %cm91 = #M91c(ref) #M91d(out) @AS $CURRENT_MIRROR;
*   %axis91 = (_, _);
*   #M91a(a) #M91b(b) %axis91(axis) @AS $MIRRORED;
*   #M91c(a) #M91d(b) %axis91(axis) @AS $MIRRORED;
*   #M91t {#M91a #M91b} @DISTANCE("bottom-to-top", min=2);
*   {#M91a #M91b} {#M91c #M91d} @DISTANCE("bottom-to-top", min=2);
*   %g92 = {#M92a #M92b #M92c #M92d #M92t} @GROUP;
*   %dp92 = #M92a(in_p) #M92b(in_n) #M92t(tail) @AS $DIFFERENTIAL_PAIR;
*   %cm92 = #M92c(ref) #M92d(out) @AS $CURRENT_MIRROR;
*   %axis92 = (_, _);
*   #M92a(a) #M92b(b) %axis92(axis) @AS $MIRRORED;
*   #M92c(a) #M92d(b) %axis92(axis) @AS $MIRRORED;
*   #M92t {#M92a #M92b} @DISTANCE("bottom-to-top", min=2);
*   {#M92a #M92b} {#M92c #M92d} @DISTANCE("bottom-to-top", min=2);
*   %g93 = {#M93a #M93b #M93c #M93d #M93t} @GROUP;
*   %dp93 = #M93a(in_p) #M93b(in_n) #M93t(tail) @AS $DIFFERENTIAL_PAIR;
*   %cm93 = #M93c(ref) #M93d(out) @AS $CURRENT_MIRROR;
*   %axis93 = (_, _);
*   #M93a(a) #M93b(b) %axis93(axis) @AS $MIRRORED;
*   #M93c(a) #M93d(b) %axis93(axis) @AS $MIRRORED;
*   #M93t {#M93a #M93b} @DISTANCE("bottom-to-top", min=2);
*   {#M93a #M93b} {#M93c #M93d} @DISTANCE("bottom-to-top", min=2);
*   %g94 = {#M94a #M94b #M94c #M94d #M94t} @GROUP;
*   %dp94 = #M94a(in_p) #M94b(in_n) #M94t(tail) @AS $DIFFERENTIAL_PAIR;
*   %cm94 = #M94c(ref) #M94d(out) @AS $CURRENT_MIRROR;
*   %axis94 = (_, _);
*   #M94a(a) #M94b(b) %axis94(axis) @AS $MIRRORED;
*   #M94c(a) #M94d(b) %axis94(axis) @AS $MIRRORED;
*   #M94t {#M94a #M94b} @DISTANCE("bottom-to-top", min=2);
*   {#M94a #M94b} {#M94c #M94d} @DISTANCE("bottom-to-top", min=2);
*   %g95 = {#M95a #M95b #M95c #M95d #M95t} @GROUP;
*   %dp95 = #M95a(in_p) #M95b(in_n) #M95t(tail) @AS $DIFFERENTIAL_PAIR;
*   %cm95 = #M95c(ref) #M95d(out) @AS $CURRENT_MIRROR;
*   %axis95 = (_, _);
*   #M95a(a) #M95b(b) %axis95(axis) @AS $MIRRORED;
*   #M95c(a) #M95d(b) %axis95(axis) @AS $MIRRORED;
*   #M95t {#M95a #M95b} @DISTANCE("bottom-to-top", min=2);
*   {#M95a #M95b} {#M95c #M95d} @DISTANCE("bottom-to-top", min=2);
*   %g96 = {#M96a #M96b #M96c #M96d #M96t} @GROUP;
*   %dp96 = #M96a(in_p) #M96b(in_n) #M96t(tail) @AS $DIFFERENTIAL_PAIR;
*   %cm96 = #M96c(ref) #M96d(out) @AS $CURRENT_MIRROR;
*   %axis96 = (_, _);
*   #M96a(a) #M96b(b) %axis96(axis) @AS $MIRRORED;
*   #M96c(a) #M96d(b) %axis96(axis) @AS $MIRRORED;
*   #M96t {#M96a #M96b} @DISTANCE("bottom-to-top", min=2);
*   {#M96a #M96b} {#M96c #M96d} @DISTANCE("bottom-to-top", min=2);
*   %g97 = {#M97a #M97b #M97c #M97d #M97t} @GROUP;
*   %dp97 = #M97a(in_p) #M97b(in_n) #M97t(tail) @AS $DIFFERENTIAL_PAIR;
*   %cm97 = #M97c(ref) #M97d(out) @AS $CURRENT_MIRROR;
*   %axis97 = (_, _);
*   #M97a(a) #M97b(b) %axis97(axis) @AS $MIRRORED;
*   #M97c(a) #M97d(b) %axis97(axis) @AS $MIRRORED;
*   #M97t {#M97a #M97b} @DISTANCE("bottom-to-top", min=2);
*   {#M97a #M97b} {#M97c #M97d} @DISTANCE("bottom-to-top", min=2);
*   %g98 = {#M98a #M98b #M98c #M98d #M98t} @GROUP;
*   %dp98 = #M98a(in_p) #M98b(in_n) #M98t(tail) @AS $DIFFERENTIAL_PAIR;
*   %cm98 = #M98c(ref) #M98d(out) @AS $CURRENT_MIRROR;
*   %axis98 = (_, _);
*   #M98a(a) #M98b(b) %axis98(axis) @AS $MIRRORED;
*   #M98c(a) #M98d(b) %axis98(axis) @AS $MIRRORED;
*   #M98t {#M98a #M98b} @DISTANCE("bottom-to-top", min=2);
*   {#M98a #M98b} {#M98c #M98d} @DISTANCE("bottom-to-top", min=2);
*   %g99 = {#M99a #M99b #M99c #M99d #M99t} @GROUP;
*   %dp99 = #M99a(in_p) #M99b(in_n) #M99t(tail) @AS $DIFFERENTIAL_PAIR;
*   %cm99 = #M99c(ref) #M99d(out) @AS $CURRENT_MIRROR;
*   %axis99 = (_, _);
*   #M99a(a) #M99b(b) %axis99(axis) @AS $MIRRORED;
*   #M99c(a) #M99d(b) %axis99(axis) @AS $MIRRORED;
*   #M99t {#M99a #M99b} @DISTANCE("bottom-to-top", min=2);
*   {#M99a #M99b} {#M99c #M99d} @DISTANCE("bottom-to-top", min=2);
*   %g100 = {#M100a #M100b #M100c #M100d #M100t} @GROUP;
*   %dp100 = #M100a(in_p) #M100b(in_n) #M100t(tail) @AS $DIFFERENTIAL_PAIR;
*   %cm100 = #M100c(ref) #M100d(out) @AS $CURRENT_MIRROR;
*   %axis100 = (_, _);
*   #M100a(a) #M100b(b) %axis100(axis) @AS $MIRRORED;
*   #M100c(a) #M100d(b) %axis100(axis) @AS $MIRRORED;
*   #M100t {#M100a #M100b} @DISTANCE("bottom-to-top", min=2);
*   {#M100a #M100b} {#M100c #M100d} @DISTANCE("bottom-to-top", min=2);
*   %g101 = {#M101a #M101b #M101c #M101d #M101t} @GROUP;
*   %dp101 = #M101a(in_p) #M101b(in_n) #M101t(tail) @AS $DIFFERENTIAL_PAIR;
*   %cm101 = #M101c(ref) #M101d(out) @AS $CURRENT_MIRROR;
*   %axis101 = (_, _);
*   #M101a(a) #M101b(b) %axis101(axis) @AS $MIRRORED;
*   #M101c(a) #M101d(b) %axis101(axis) @AS $MIRRORED;
*   #M101t {#M101a #M101b} @DISTANCE("bottom-to-top", min=2);
*   {#M101a #M101b} {#M101c #M101d} @DISTANCE("bottom-to-top", min=2);
*   %g102 = {#M102a #M102b #M102c #M102d #M102t} @GROUP;
*   %dp102 = #M102a(in_p) #M102b(in_n) #M102t(tail) @AS $DIFFERENTIAL_PAIR;
*   %cm102 = #M102c(ref) #M102d(out) @AS $CURRENT_MIRROR;
*   %axis102 = (_, _);
*   #M102a(a) #M102b(b) %axis102(axis) @AS $MIRRORED;
*   #M102c(a) #M102d(b) %axis102(axis) @AS $MIRRORED;
*   #M102t {#M102a #M102b} @DISTANCE("bottom-to-top", min=2);
*   {#M102a #M102b} {#M102c #M102d} @DISTANCE("bottom-to-top", min=2);
*   %g103 = {#M103a #M103b #M103c #M103d #M103t} @GROUP;
*   %dp103 = #M103a(in_p) #M103b(in_n) #M103t(tail) @AS $DIFFERENTIAL_PAIR;
*   %cm103 = #M103c(ref) #M103d(out) @AS $CURRENT_MIRROR;
*   %axis103 = (_, _);
*   #M103a(a) #M103b(b) %axis103(axis) @AS $MIRRORED;
*   #M103c(a) #M103d(b) %axis103(axis) @AS $MIRRORED;
*   #M103t {#M103a #M103b} @DISTANCE("bottom-to-top", min=2);
*   {#M103a #M103b} {#M103c #M103d} @DISTANCE("bottom-to-top", min=2);
*   %g104 = {#M104a #M104b #M104c #M104d #M104t} @GROUP;
*   %dp104 = #M104a(in_p) #M104b(in_n) #M104t(tail) @AS $DIFFERENTIAL_PAIR;
*   %cm104 = #M104c(ref) #M104d(out) @AS $CURRENT_MIRROR;
*   %axis104 = (_, _);
*   #M104a(a) #M104b(b) %axis104(axis) @AS $MIRRORED;
*   #M104c(a) #M104d(b) %axis104(axis) @AS $MIRRORED;
*   #M104t {#M104a #M104b} @DISTANCE("bottom-to-top", min=2);
*   {#M104a #M104b} {#M104c #M104d} @DISTANCE("bottom-to-top", min=2);
*   %g105 = {#M105a #M105b #M105c #M105d #M105t} @GROUP;
*   %dp105 = #M105a(in_p) #M105b(in_n) #M105t(tail) @AS $DIFFERENTIAL_PAIR;
*   %cm105 = #M105c(ref) #M105d(out) @AS $CURRENT_MIRROR;
*   %axis105 = (_, _);
*   #M105a(a) #M105b(b) %axis105(axis) @AS $MIRRORED;
*   #M105c(a) #M105d(b) %axis105(axis) @AS $MIRRORED;
*   #M105t {#M105a #M105b} @DISTANCE("bottom-to-top", min=2);
*   {#M105a #M105b} {#M105c #M105d} @DISTANCE("bottom-to-top", min=2);
*   %g106 = {#M106a #M106b #M106c #M106d #M106t} @GROUP;
*   %dp106 = #M106a(in_p) #M106b(in_n) #M106t(tail) @AS $DIFFERENTIAL_PAIR;
*   %cm106 = #M106c(ref) #M106d(out) @AS $CURRENT_MIRROR;
*   %axis106 = (_, _);
*   #M106a(a) #M106b(b) %axis106(axis) @AS $MIRRORED;
*   #M106c(a) #M106d(b) %axis106(axis) @AS $MIRRORED;
*   #M106t {#M106a #M106b} @DISTANCE("bottom-to-top", min=2);
*   {#M106a #M106b} {#M106c #M106d} @DISTANCE("bottom-to-top", min=2);
*   %g107 = {#M107a #M107b #M107c #M107d #M107t} @GROUP;
*   %dp107 = #M107a(in_p) #M107b(in_n) #M107t(tail) @AS $DIFFERENTIAL_PAIR;
*   %cm107 = #M107c(ref) #M107d(out) @AS $CURRENT_MIRROR;
*   %axis107 = (_, _);
*   #M107a(a) #M107b(b) %axis107(axis) @AS $MIRRORED;
*   #M107c(a) #M107d(b) %axis107(axis) @AS $MIRRORED;
*   #M107t {#M107a #M107b} @DISTANCE("bottom-to-top", min=2);
*   {#M107a #M107b} {#M107c #M107d} @DISTANCE("bottom-to-top", min=2);
*   %g108 = {#M108a #M108b #M108c #M108d #M108t} @GROUP;
*   %dp108 = #M108a(in_p) #M108b(in_n) #M108t(tail) @AS $DIFFERENTIAL_PAIR;
*   %cm108 = #M108c(ref) #M108d(out) @AS $CURRENT_MIRROR;
*   %axis108 = (_, _);
*   #M108a(a) #M108b(b) %axis108(axis) @AS $MIRRORED;
*   #M108c(a) #M108d(b) %axis108(axis) @AS $MIRRORED;
*   #M108t {#M108a #M108b} @DISTANCE("bottom-to-top", min=2);
*   {#M108a #M108b} {#M108c #M108d} @DISTANCE("bottom-to-top", min=2);
*   %g109 = {#M109a #M109b #M109c #M109d #M109t} @GROUP;
*   %dp109 = #M109a(in_p) #M109b(in_n) #M109t(tail) @AS $DIFFERENTIAL_PAIR;
*   %cm109 = #M109c(ref) #M109d(out) @AS $CURRENT_MIRROR;
*   %axis109 = (_, _);
*   #M109a(a) #M109b(b) %axis109(axis) @AS $MIRRORED;
*   #M109c(a) #M109d(b) %axis109(axis) @AS $MIRRORED;
*   #M109t {#M109a #M109b} @DISTANCE("bottom-to-top", min=2);
*   {#M109a #M109b} {#M109c #M109d} @DISTANCE("bottom-to-top", min=2);
*   %g110 = {#M110a #M110b #M110c #M110d #M110t} @GROUP;
*   %dp110 = #M110a(in_p) #M110b(in_n) #M110t(tail) @AS $DIFFERENTIAL_PAIR;
*   %cm110 = #M110c(ref) #M110d(out) @AS $CURRENT_MIRROR;
*   %axis110 = (_, _);
*   #M110a(a) #M110b(b) %axis110(axis) @AS $MIRRORED;
*   #M110c(a) #M110d(b) %axis110(axis) @AS $MIRRORED;
*   #M110t {#M110a #M110b} @DISTANCE("bottom-to-top", min=2);
*   {#M110a #M110b} {#M110c #M110d} @DISTANCE("bottom-to-top", min=2);
*   %g111 = {#M111a #M111b #M111c #M111d #M111t} @GROUP;
*   %dp111 = #M111a(in_p) #M111b(in_n) #M111t(tail) @AS $DIFFERENTIAL_PAIR;
*   %cm111 = #M111c(ref) #M111d(out) @AS $CURRENT_MIRROR;
*   %axis111 = (_, _);
*   #M111a(a) #M111b(b) %axis111(axis) @AS $MIRRORED;
*   #M111c(a) #M111d(b) %axis111(axis) @AS $MIRRORED;
*   #M111t {#M111a #M111b} @DISTANCE("bottom-to-top", min=2);
*   {#M111a #M111b} {#M111c #M111d} @DISTANCE("bottom-to-top", min=2);
*   %g112 = {#M112a #M112b #M112c #M112d #M112t} @GROUP;
*   %dp112 = #M112a(in_p) #M112b(in_n) #M112t(tail) @AS $DIFFERENTIAL_PAIR;
*   %cm112 = #M112c(ref) #M112d(out) @AS $CURRENT_MIRROR;
*   %axis112 = (_, _);
*   #M112a(a) #M112b(b) %axis112(axis) @AS $MIRRORED;
*   #M112c(a) #M112d(b) %axis112(axis) @AS $MIRRORED;
*   #M112t {#M112a #M112b} @DISTANCE("bottom-to-top", min=2);
*   {#M112a #M112b} {#M112c #M112d} @DISTANCE("bottom-to-top", min=2);
*   %g113 = {#M113a #M113b #M113c #M113d #M113t} @GROUP;
*   %dp113 = #M113a(in_p) #M113b(in_n) #M113t(tail) @AS $DIFFERENTIAL_PAIR;
*   %cm113 = #M113c(ref) #M113d(out) @AS $CURRENT_MIRROR;
*   %axis113 = (_, _);
*   #M113a(a) #M113b(b) %axis113(axis) @AS $MIRRORED;
*   #M113c(a) #M113d(b) %axis113(axis) @AS $MIRRORED;
*   #M113t {#M113a #M113b} @DISTANCE("bottom-to-top", min=2);
*   {#M113a #M113b} {#M113c #M113d} @DISTANCE("bottom-to-top", min=2);
*   %g114 = {#M114a #M114b #M114c #M114d #M114t} @GROUP;
*   %dp114 = #M114a(in_p) #M114b(in_n) #M114t(tail) @AS $DIFFERENTIAL_PAIR;
*   %cm114 = #M114c(ref) #M114d(out) @AS $CURRENT_MIRROR;
*   %axis114 = (_, _);
*   #M114a(a) #M114b(b) %axis114(axis) @AS $MIRRORED;
*   #M114c(a) #M114d(b) %axis114(axis) @AS $MIRRORED;
*   #M114t {#M114a #M114b} @DISTANCE("bottom-to-top", min=2);
*   {#M114a #M114b} {#M114c #M114d} @DISTANCE("bottom-to-top", min=2);
*   %g115 = {#M115a #M115b #M115c #M115d #M115t} @GROUP;
*   %dp115 = #M115a(in_p) #M115b(in_n) #M115t(tail) @AS $DIFFERENTIAL_PAIR;
*   %cm115 = #M115c(ref) #M115d(out) @AS $CURRENT_MIRROR;
*   %axis115 = (_, _);
*   #M115a(a) #M115b(b) %axis115(axis) @AS $MIRRORED;
*   #M115c(a) #M115d(b) %axis115(axis) @AS $MIRRORED;
*   #M115t {#M115a #M115b} @DISTANCE("bottom-to-top", min=2);
*   {#M115a #M115b} {#M115c #M115d} @DISTANCE("bottom-to-top", min=2);
*   %g116 = {#M116a #M116b #M116c #M116d #M116t} @GROUP;
*   %dp116 = #M116a(in_p) #M116b(in_n) #M116t(tail) @AS $DIFFERENTIAL_PAIR;
*   %cm116 = #M116c(ref) #M116d(out) @AS $CURRENT_MIRROR;
*   %axis116 = (_, _);
*   #M116a(a) #M116b(b) %axis116(axis) @AS $MIRRORED;
*   #M116c(a) #M116d(b) %axis116(axis) @AS $MIRRORED;
*   #M116t {#M116a #M116b} @DISTANCE("bottom-to-top", min=2);
*   {#M116a #M116b} {#M116c #M116d} @DISTANCE("bottom-to-top", min=2);
*   %g117 = {#M117a #M117b #M117c #M117d #M117t} @GROUP;
*   %dp117 = #M117a(in_p) #M117b(in_n) #M117t(tail) @AS $DIFFERENTIAL_PAIR;
*   %cm117 = #M117c(ref) #M117d(out) @AS $CURRENT_MIRROR;
*   %axis117 = (_, _);
*   #M117a(a) #M117b(b) %axis117(axis) @AS $MIRRORED;
*   #M117c(a) #M117d(b) %axis117(axis) @AS $MIRRORED;
*   #M117t {#M117a #M117b} @DISTANCE("bottom-to-top", min=2);
*   {#M117a #M117b} {#M117c #M117d} @DISTANCE("bottom-to-top", min=2);
*   %g118 = {#M118a #M118b #M118c #M118d #M118t} @GROUP;
*   %dp118 = #M118a(in_p) #M118b(in_n) #M118t(tail) @AS $DIFFERENTIAL_PAIR;
*   %cm118 = #M118c(ref) #M118d(out) @AS $CURRENT_MIRROR;
*   %axis118 = (_, _);
*   #M118a(a) #M118b(b) %axis118(axis) @AS $MIRRORED;
*   #M118c(a) #M118d(b) %axis118(axis) @AS $MIRRORED;
*   #M118t {#M118a #M118b} @DISTANCE("bottom-to-top", min=2);
*   {#M118a #M118b} {#M118c #M118d} @DISTANCE("bottom-to-top", min=2);
*   %g119 = {#M119a #M119b #M119c #M119d #M119t} @GROUP;
*   %dp119 = #M119a(in_p) #M119b(in_n) #M119t(tail) @AS $DIFFERENTIAL_PAIR;
*   %cm119 = #M119c(ref) #M119d(out) @AS $CURRENT_MIRROR;
*   %axis119 = (_, _);
*   #M119a(a) #M119b(b) %axis119(axis) @AS $MIRRORED;
*   #M119c(a) #M119d(b) %axis119(axis) @AS $MIRRORED;
*   #M119t {#M119a #M119b} @DISTANCE("bottom-to-top", min=2);
*   {#M119a #M119b} {#M119c #M119d} @DISTANCE("bottom-to-top", min=2);
*   %g120 = {#M120a #M120b #M120c #M120d #M120t} @GROUP;
*   %dp120 = #M120a(in_p) #M120b(in_n) #M120t(tail) @AS $DIFFERENTIAL_PAIR;
*   %cm120 = #M120c(ref) #M120d(out) @AS $CURRENT_MIRROR;
*   %axis120 = (_, _);
*   #M120a(a) #M120b(b) %axis120(axis) @AS $MIRRORED;
*   #M120c(a) #M120d(b) %axis120(axis) @AS $MIRRORED;
*   #M120t {#M120a #M120b} @DISTANCE("bottom-to-top", min=2);
*   {#M120a #M120b} {#M120c #M120d} @DISTANCE("bottom-to-top", min=2);
*   %g121 = {#M121a #M121b #M121c #M121d #M121t} @GROUP;
*   %dp121 = #M121a(in_p) #M121b(in_n) #M121t(tail) @AS $DIFFERENTIAL_PAIR;
*   %cm121 = #M121c(ref) #M121d(out) @AS $CURRENT_MIRROR;
*   %axis121 = (_, _);
*   #M121a(a) #M121b(b) %axis121(axis) @AS $MIRRORED;
*   #M121c(a) #M121d(b) %axis121(axis) @AS $MIRRORED;
*   #M121t {#M121a #M121b} @DISTANCE("bottom-to-top", min=2);
*   {#M121a #M121b} {#M121c #M121d} @DISTANCE("bottom-to-top", min=2);
*   %g122 = {#M122a #M122b #M122c #M122d #M122t} @GROUP;
*   %dp122 = #M122a(in_p) #M122b(in_n) #M122t(tail) @AS $DIFFERENTIAL_PAIR;
*   %cm122 = #M122c(ref) #M122d(out) @AS $CURRENT_MIRROR;
*   %axis122 = (_, _);
*   #M122a(a) #M122b(b) %axis122(axis) @AS $MIRRORED;
*   #M122c(a) #M122d(b) %axis122(axis) @AS $MIRRORED;
*   #M122t {#M122a #M122b} @DISTANCE("bottom-to-top", min=2);
*   {#M122a #M122b} {#M122c #M122d} @DISTANCE("bottom-to-top", min=2);
*   %g123 = {#M123a #M123b #M123c #M123d #M123t} @GROUP;
*   %dp123 = #M123a(in_p) #M123b(in_n) #M123t(tail) @AS $DIFFERENTIAL_PAIR;
*   %cm123 = #M123c(ref) #M123d(out) @AS $CURRENT_MIRROR;
*   %axis123 = (_, _);
*   #M123a(a) #M123b(b) %axis123(axis) @AS $MIRRORED;
*   #M123c(a) #M123d(b) %axis123(axis) @AS $MIRRORED;
*   #M123t {#M123a #M123b} @DISTANCE("bottom-to-top", min=2);
*   {#M123a #M123b} {#M123c #M123d} @DISTANCE("bottom-to-top", min=2);
*   %g124 = {#M124a #M124b #M124c #M124d #M124t} @GROUP;
*   %dp124 = #M124a(in_p) #M124b(in_n) #M124t(tail) @AS $DIFFERENTIAL_PAIR;
*   %cm124 = #M124c(ref) #M124d(out) @AS $CURRENT_MIRROR;
*   %axis124 = (_, _);
*   #M124a(a) #M124b(b) %axis124(axis) @AS $MIRRORED;
*   #M124c(a) #M124d(b) %axis124(axis) @AS $MIRRORED;
*   #M124t {#M124a #M124b} @DISTANCE("bottom-to-top", min=2);
*   {#M124a #M124b} {#M124c #M124d} @DISTANCE("bottom-to-top", min=2);
*   %g125 = {#M125a #M125b #M125c #M125d #M125t} @GROUP;
*   %dp125 = #M125a(in_p) #M125b(in_n) #M125t(tail) @AS $DIFFERENTIAL_PAIR;
*   %cm125 = #M125c(ref) #M125d(out) @AS $CURRENT_MIRROR;
*   %axis125 = (_, _);
*   #M125a(a) #M125b(b) %axis125(axis) @AS $MIRRORED;
*   #M125c(a) #M125d(b) %axis125(axis) @AS $MIRRORED;
*   #M125t {#M125a #M125b} @DISTANCE("bottom-to-top", min=2);
*   {#M125a #M125b} {#M125c #M125d} @DISTANCE("bottom-to-top", min=2);
*   %g126 = {#M126a #M126b #M126c #M126d #M126t} @GROUP;
*   %dp126 = #M126a(in_p) #M126b(in_n) #M126t(tail) @AS $DIFFERENTIAL_PAIR;
*   %cm126 = #M126c(ref) #M126d(out) @AS $CURRENT_MIRROR;
*   %axis126 = (_, _);
*   #M126a(a) #M126b(b) %axis126(axis) @AS $MIRRORED;
*   #M126c(a) #M126d(b) %axis126(axis) @AS $MIRRORED;
*   #M126t {#M126a #M126b} @DISTANCE("bottom-to-top", min=2);
*   {#M126a #M126b} {#M126c #M126d} @DISTANCE("bottom-to-top", min=2);
*   %g127 = {#M127a #M127b #M127c #M127d #M127t} @GROUP;
*   %dp127 = #M127a(in_p) #M127b(in_n) #M127t(tail) @AS $DIFFERENTIAL_PAIR;
*   %cm127 = #M127c(ref) #M127d(out) @AS $CURRENT_MIRROR;
*   %axis127 = (_, _);
*   #M127a(a) #M127b(b) %axis127(axis) @AS $MIRRORED;
*   #M127c(a) #M127d(b) %axis127(axis) @AS $MIRRORED;
*   #M127t {#M127a #M127b} @DISTANCE("bottom-to-top", min=2);
*   {#M127a #M127b} {#M127c #M127d} @DISTANCE("bottom-to-top", min=2);
*   %g128 = {#M128a #M128b #M128c #M128d #M128t} @GROUP;
*   %dp128 = #M128a(in_p) #M128b(in_n) #M128t(tail) @AS $DIFFERENTIAL_PAIR;
*   %cm128 = #M128c(ref) #M128d(out) @AS $CURRENT_MIRROR;
*   %axis128 = (_, _);
*   #M128a(a) #M128b(b) %axis128(axis) @AS $MIRRORED;
*   #M128c(a) #M128d(b) %axis128(axis) @AS $MIRRORED;
*   #M128t {#M128a #M128b} @DISTANCE("bottom-to-top", min=2);
*   {#M128a #M128b} {#M128c #M128d} @DISTANCE("bottom-to-top", min=2);
*   %g129 = {#M129a #M129b #M129c #M129d #M129t} @GROUP;
*   %dp129 = #M129a(in_p) #M129b(in_n) #M129t(tail) @AS $DIFFERENTIAL_PAIR;
*   %cm129 = #M129c(ref) #M129d(out) @AS $CURRENT_MIRROR;
*   %axis129 = (_, _);
*   #M129a(a) #M129b(b) %axis129(axis) @AS $MIRRORED;
*   #M129c(a) #M129d(b) %axis129(axis) @AS $MIRRORED;
*   #M129t {#M129a #M129b} @DISTANCE("bottom-to-top", min=2);
*   {#M129a #M129b} {#M129c #M129d} @DISTANCE("bottom-to-top", min=2);
*   %g130 = {#M130a #M130b #M130c #M130d #M130t} @GROUP;
*   %dp130 = #M130a(in_p) #M130b(in_n) #M130t(tail) @AS $DIFFERENTIAL_PAIR;
*   %cm130 = #M130c(ref) #M130d(out) @AS $CURRENT_MIRROR;
*   %axis130 = (_, _);
*   #M130a(a) #M130b(b) %axis130(axis) @AS $MIRRORED;
*   #M130c(a) #M130d(b) %axis130(axis) @AS $MIRRORED;
*   #M130t {#M130a #M130b} @DISTANCE("bottom-to-top", min=2);
*   {#M130a #M130b} {#M130c #M130d} @DISTANCE("bottom-to-top", min=2);
*   %g131 = {#M131a #M131b #M131c #M131d #M131t} @GROUP;
*   %dp131 = #M131a(in_p) #M131b(in_n) #M131t(tail) @AS $DIFFERENTIAL_PAIR;
*   %cm131 = #M131c(ref) #M131d(out) @AS $CURRENT_MIRROR;
*   %axis131 = (_, _);
*   #M131a(a) #M131b(b) %axis131(axis) @AS $MIRRORED;
*   #M131c(a) #M131d(b) %axis131(axis) @AS $MIRRORED;
*   #M131t {#M131a #M131b} @DISTANCE("bottom-to-top", min=2);
*   {#M131a #M131b} {#M131c #M131d} @DISTANCE("bottom-to-top", min=2);
*   %g132 = {#M132a #M132b #M132c #M132d #M132t} @GROUP;
*   %dp132 = #M132a(in_p) #M132b(in_n) #M132t(tail) @AS $DIFFERENTIAL_PAIR;
*   %cm132 = #M132c(ref) #M132d(out) @AS $CURRENT_MIRROR;
*   %axis132 = (_, _);
*   #M132a(a) #M132b(b) %axis132(axis) @AS $MIRRORED;
*   #M132c(a) #M132d(b) %axis132(axis) @AS $MIRRORED;
*   #M132t {#M132a #M132b} @DISTANCE("bottom-to-top", min=2);
*   {#M132a #M132b} {#M132c #M132d} @DISTANCE("bottom-to-top", min=2);
*   %g133 = {#M133a #M133b #M133c #M133d #M133t} @GROUP;
*   %dp133 = #M133a(in_p) #M133b(in_n) #M133t(tail) @AS $DIFFERENTIAL_PAIR;
*   %cm133 = #M133c(ref) #M133d(out) @AS $CURRENT_MIRROR;
*   %axis133 = (_, _);
*   #M133a(a) #M133b(b) %axis133(axis) @AS $MIRRORED;
*   #M133c(a) #M133d(b) %axis133(axis) @AS $MIRRORED;
*   #M133t {#M133a #M133b} @DISTANCE("bottom-to-top", min=2);
*   {#M133a #M133b} {#M133c #M133d} @DISTANCE("bottom-to-top", min=2);
*   %g134 = {#M134a #M134b #M134c #M134d #M134t} @GROUP;
*   %dp134 = #M134a(in_p) #M134b(in_n) #M134t(tail) @AS $DIFFERENTIAL_PAIR;
*   %cm134 = #M134c(ref) #M134d(out) @AS $CURRENT_MIRROR;
*   %axis134 = (_, _);
*   #M134a(a) #M134b(b) %axis134(axis) @AS $MIRRORED;
*   #M134c(a) #M134d(b) %axis134(axis) @AS $MIRRORED;
*   #M134t {#M134a #M134b} @DISTANCE("bottom-to-top", min=2);
*   {#M134a #M134b} {#M134c #M134d} @DISTANCE("bottom-to-top", min=2);
*   %g135 = {#M135a #M135b #M135c #M135d #M135t} @GROUP;
*   %dp135 = #M135a(in_p) #M135b(in_n) #M135t(tail) @AS $DIFFERENTIAL_PAIR;
*   %cm135 = #M135c(ref) #M135d(out) @AS $CURRENT_MIRROR;
*   %axis135 = (_, _);
*   #M135a(a) #M135b(b) %axis135(axis) @AS $MIRRORED;
*   #M135c(a) #M135d(b) %axis135(axis) @AS $MIRRORED;
*   #M135t {#M135a #M135b} @DISTANCE("bottom-to-top", min=2);
*   {#M135a #M135b} {#M135c #M135d} @DISTANCE("bottom-to-top", min=2);
*   %g136 = {#M136a #M136b #M136c #M136d #M136t} @GROUP;
*   %dp136 = #M136a(in_p) #M136b(in_n) #M136t(tail) @AS $DIFFERENTIAL_PAIR;
*   %cm136 = #M136c(ref) #M136d(out) @AS $CURRENT_MIRROR;
*   %axis136 = (_, _);
*   #M136a(a) #M136b(b) %axis136(axis) @AS $MIRRORED;
*   #M136c(a) #M136d(b) %axis136(axis) @AS $MIRRORED;
*   #M136t {#M136a #M136b} @DISTANCE("bottom-to-top", min=2);
*   {#M136a #M136b} {#M136c #M136d} @DISTANCE("bottom-to-top", min=2);
*   %g137 = {#M137a #M137b #M137c #M137d #M137t} @GROUP;
*   %dp137 = #M137a(in_p) #M137b(in_n) #M137t(tail) @AS $DIFFERENTIAL_PAIR;
*   %cm137 = #M137c(ref) #M137d(out) @AS $CURRENT_MIRROR;
*   %axis137 = (_, _);
*   #M137a(a) #M137b(b) %axis137(axis) @AS $MIRRORED;
*   #M137c(a) #M137d(b) %axis137(axis) @AS $MIRRORED;
*   #M137t {#M137a #M137b} @DISTANCE("bottom-to-top", min=2);
*   {#M137a #M137b} {#M137c #M137d} @DISTANCE("bottom-to-top", min=2);
*   %g138 = {#M138a #M138b #M138c #M138d #M138t} @GROUP;
*   %dp138 = #M138a(in_p) #M138b(in_n) #M138t(tail) @AS $DIFFERENTIAL_PAIR;
*   %cm138 = #M138c(ref) #M138d(out) @AS $CURRENT_MIRROR;
*   %axis138 = (_, _);
*   #M138a(a) #M138b(b) %axis138(axis) @AS $MIRRORED;
*   #M138c(a) #M138d(b) %axis138(axis) @AS $MIRRORED;
*   #M138t {#M138a #M138b} @DISTANCE("bottom-to-top", min=2);
*   {#M138a #M138b} {#M138c #M138d} @DISTANCE("bottom-to-top", min=2);
*   %g139 = {#M139a #M139b #M139c #M139d #M139t} @GROUP;
*   %dp139 = #M139a(in_p) #M139b(in_n) #M139t(tail) @AS $DIFFERENTIAL_PAIR;
*   %cm139 = #M139c(ref) #M139d(out) @AS $CURRENT_MIRROR;
*   %axis139 = (_, _);
*   #M139a(a) #M139b(b) %axis139(axis) @AS $MIRRORED;
*   #M139c(a) #M139d(b) %axis139(axis) @AS $MIRRORED;
*   #M139t {#M139a #M139b} @DISTANCE("bottom-to-top", min=2);
*   {#M139a #M139b} {#M139c #M139d} @DISTANCE("bottom-to-top", min=2);
*   %g140 = {#M140a #M140b #M140c #M140d #M140t} @GROUP;
*   %dp140 = #M140a(in_p) #M140b(in_n) #M140t(tail) @AS $DIFFERENTIAL_PAIR;
*   %cm140 = #M140c(ref) #M140d(out) @AS $CURRENT_MIRROR;
*   %axis140 = (_, _);
*   #M140a(a) #M140b(b) %axis140(axis) @AS $MIRRORED;
*   #M140c(a) #M140d(b) %axis140(axis) @AS $MIRRORED;
*   #M140t {#M140a #M140b} @DISTANCE("bottom-to-top", min=2);
*   {#M140a #M140b} {#M140c #M140d} @DISTANCE("bottom-to-top", min=2);
*   %g141 = {#M141a #M141b #M141c #M141d #M141t} @GROUP;
*   %dp141 = #M141a(in_p) #M141b(in_n) #M141t(tail) @AS $DIFFERENTIAL_PAIR;
*   %cm141 = #M141c(ref) #M141d(out) @AS $CURRENT_MIRROR;
*   %axis141 = (_, _);
*   #M141a(a) #M141b(b) %axis141(axis) @AS $MIRRORED;
*   #M141c(a) #M141d(b) %axis141(axis) @AS $MIRRORED;
*   #M141t {#M141a #M141b} @DISTANCE("bottom-to-top", min=2);
*   {#M141a #M141b} {#M141c #M141d} @DISTANCE("bottom-to-top", min=2);
*   %g142 = {#M142a #M142b #M142c #M142d #M142t} @GROUP;
*   %dp142 = #M142a(in_p) #M142b(in_n) #M142t(tail) @AS $DIFFERENTIAL_PAIR;
*   %cm142 = #M142c(ref) #M142d(out) @AS $CURRENT_MIRROR;
*   %axis142 = (_, _);
*   #M142a(a) #M142b(b) %axis142(axis) @AS $MIRRORED;
*   #M142c(a) #M142d(b) %axis142(axis) @AS $MIRRORED;
*   #M142t {#M142a #M142b} @DISTANCE("bottom-to-top", min=2);
*   {#M142a #M142b} {#M142c #M142d} @DISTANCE("bottom-to-top", min=2);
*   %g143 = {#M143a #M143b #M143c #M143d #M143t} @GROUP;
*   %dp143 = #M143a(in_p) #M143b(in_n) #M143t(tail) @AS $DIFFERENTIAL_PAIR;
*   %cm143 = #M143c(ref) #M143d(out) @AS $CURRENT_MIRROR;
*   %axis143 = (_, _);
*   #M143a(a) #M143b(b) %axis143(axis) @AS $MIRRORED;
*   #M143c(a) #M143d(b) %axis143(axis) @AS $MIRRORED;
*   #M143t {#M143a #M143b} @DISTANCE("bottom-to-top", min=2);
*   {#M143a #M143b} {#M143c #M143d} @DISTANCE("bottom-to-top", min=2);
*   %g144 = {#M144a #M144b #M144c #M144d #M144t} @GROUP;
*   %dp144 = #M144a(in_p) #M144b(in_n) #M144t(tail) @AS $DIFFERENTIAL_PAIR;
*   %cm144 = #M144c(ref) #M144d(out) @AS $CURRENT_MIRROR;
*   %axis144 = (_, _);
*   #M144a(a) #M144b(b) %axis144(axis) @AS $MIRRORED;
*   #M144c(a) #M144d(b) %axis144(axis) @AS $MIRRORED;
*   #M144t {#M144a #M144b} @DISTANCE("bottom-to-top", min=2);
*   {#M144a #M144b} {#M144c #M144d} @DISTANCE("bottom-to-top", min=2);
*   %g145 = {#M145a #M145b #M145c #M145d #M145t} @GROUP;
*   %dp145 = #M145a(in_p) #M145b(in_n) #M145t(tail) @AS $DIFFERENTIAL_PAIR;
*   %cm145 = #M145c(ref) #M145d(out) @AS $CURRENT_MIRROR;
*   %axis145 = (_, _);
*   #M145a(a) #M145b(b) %axis145(axis) @AS $MIRRORED;
*   #M145c(a) #M145d(b) %axis145(axis) @AS $MIRRORED;
*   #M145t {#M145a #M145b} @DISTANCE("bottom-to-top", min=2);
*   {#M145a #M145b} {#M145c #M145d} @DISTANCE("bottom-to-top", min=2);
*   %g146 = {#M146a #M146b #M146c #M146d #M146t} @GROUP;
*   %dp146 = #M146a(in_p) #M146b(in_n) #M146t(tail) @AS $DIFFERENTIAL_PAIR;
*   %cm146 = #M146c(ref) #M146d(out) @AS $CURRENT_MIRROR;
*   %axis146 = (_, _);
*   #M146a(a) #M146b(b) %axis146(axis) @AS $MIRRORED;
*   #M146c(a) #M146d(b) %axis146(axis) @AS $MIRRORED;
*   #M146t {#M146a #M146b} @DISTANCE("bottom-to-top", min=2);
*   {#M146a #M146b} {#M146c #M146d} @DISTANCE("bottom-to-top", min=2);
*   %g147 = {#M147a #M147b #M147c #M147d #M147t} @GROUP;
*   %dp147 = #M147a(in_p) #M147b(in_n) #M147t(tail) @AS $DIFFERENTIAL_PAIR;
*   %cm147 = #M147c(ref) #M147d(out) @AS $CURRENT_MIRROR;
*   %axis147 = (_, _);
*   #M147a(a) #M147b(b) %axis147(axis) @AS $MIRRORED;
*   #M147c(a) #M147d(b) %axis147(axis) @AS $MIRRORED;
*   #M147t {#M147a #M147b} @DISTANCE("bottom-to-top", min=2);
*   {#M147a #M147b} {#M147c #M147d} @DISTANCE("bottom-to-top", min=2);
*   %g148 = {#M148a #M148b #M148c #M148d #M148t} @GROUP;
*   %dp148 = #M148a(in_p) #M148b(in_n) #M148t(tail) @AS $DIFFERENTIAL_PAIR;
*   %cm148 = #M148c(ref) #M148d(out) @AS $CURRENT_MIRROR;
*   %axis148 = (_, _);
*   #M148a(a) #M148b(b) %axis148(axis) @AS $MIRRORED;
*   #M148c(a) #M148d(b) %axis148(axis) @AS $MIRRORED;
*   #M148t {#M148a #M148b} @DISTANCE("bottom-to-top", min=2);
*   {#M148a #M148b} {#M148c #M148d} @DISTANCE("bottom-to-top", min=2);
*   %g149 = {#M149a #M149b #M149c #M149d #M149t} @GROUP;
*   %dp149 = #M149a(in_p) #M149b(in_n) #M149t(tail) @AS $DIFFERENTIAL_PAIR;
*   %cm149 = #M149c(ref) #M149d(out) @AS $CURRENT_MIRROR;
*   %axis149 = (_, _);
*   #M149a(a) #M149b(b) %axis149(axis) @AS $MIRRORED;
*   #M149c(a) #M149d(b) %axis149(axis) @AS $MIRRORED;
*   #M149t {#M149a #M149b} @DISTANCE("bottom-to-top", min=2);
*   {#M149a #M149b} {#M149c #M149d} @DISTANCE("bottom-to-top", min=2);
*   %g150 = {#M150a #M150b #M150c #M150d #M150t} @GROUP;
*   %dp150 = #M150a(in_p) #M150b(in_n) #M150t(tail) @AS $DIFFERENTIAL_PAIR;
*   %cm150 = #M150c(ref) #M150d(out) @AS $CURRENT_MIRROR;
*   %axis150 = (_, _);
*   #M150a(a) #M150b(b) %axis150(axis) @AS $MIRRORED;
*   #M150c(a) #M150d(b) %axis150(axis) @AS $MIRRORED;
*   #M150t {#M150a #M150b} @DISTANCE("bottom-to-top", min=2);
*   {#M150a #M150b} {#M150c #M150d} @DISTANCE("bottom-to-top", min=2);
*   %g151 = {#M151a #M151b #M151c #M151d #M151t} @GROUP;
*   %dp151 = #M151a(in_p) #M151b(in_n) #M151t(tail) @AS $DIFFERENTIAL_PAIR;
*   %cm151 = #M151c(ref) #M151d(out) @AS $CURRENT_MIRROR;
*   %axis151 = (_, _);
*   #M151a(a) #M151b(b) %axis151(axis) @AS $MIRRORED;
*   #M151c(a) #M151d(b) %axis151(axis) @AS $MIRRORED;
*   #M151t {#M151a #M151b} @DISTANCE("bottom-to-top", min=2);
*   {#M151a #M151b} {#M151c #M151d} @DISTANCE("bottom-to-top", min=2);
*   %g152 = {#M152a #M152b #M152c #M152d #M152t} @GROUP;
*   %dp152 = #M152a(in_p) #M152b(in_n) #M152t(tail) @AS $DIFFERENTIAL_PAIR;
*   %cm152 = #M152c(ref) #M152d(out) @AS $CURRENT_MIRROR;
*   %axis152 = (_, _);
*   #M152a(a) #M152b(b) %axis152(axis) @AS $MIRRORED;
*   #M152c(a) #M152d(b) %axis152(axis) @AS $MIRRORED;
*   #M152t {#M152a #M152b} @DISTANCE("bottom-to-top", min=2);
*   {#M152a #M152b} {#M152c #M152d} @DISTANCE("bottom-to-top", min=2);
*   %g153 = {#M153a #M153b #M153c #M153d #M153t} @GROUP;
*   %dp153 = #M153a(in_p) #M153b(in_n) #M153t(tail) @AS $DIFFERENTIAL_PAIR;
*   %cm153 = #M153c(ref) #M153d(out) @AS $CURRENT_MIRROR;
*   %axis153 = (_, _);
*   #M153a(a) #M153b(b) %axis153(axis) @AS $MIRRORED;
*   #M153c(a) #M153d(b) %axis153(axis) @AS $MIRRORED;
*   #M153t {#M153a #M153b} @DISTANCE("bottom-to-top", min=2);
*   {#M153a #M153b} {#M153c #M153d} @DISTANCE("bottom-to-top", min=2);
*   %g154 = {#M154a #M154b #M154c #M154d #M154t} @GROUP;
*   %dp154 = #M154a(in_p) #M154b(in_n) #M154t(tail) @AS $DIFFERENTIAL_PAIR;
*   %cm154 = #M154c(ref) #M154d(out) @AS $CURRENT_MIRROR;
*   %axis154 = (_, _);
*   #M154a(a) #M154b(b) %axis154(axis) @AS $MIRRORED;
*   #M154c(a) #M154d(b) %axis154(axis) @AS $MIRRORED;
*   #M154t {#M154a #M154b} @DISTANCE("bottom-to-top", min=2);
*   {#M154a #M154b} {#M154c #M154d} @DISTANCE("bottom-to-top", min=2);
*   %g155 = {#M155a #M155b #M155c #M155d #M155t} @GROUP;
*   %dp155 = #M155a(in_p) #M155b(in_n) #M155t(tail) @AS $DIFFERENTIAL_PAIR;
*   %cm155 = #M155c(ref) #M155d(out) @AS $CURRENT_MIRROR;
*   %axis155 = (_, _);
*   #M155a(a) #M155b(b) %axis155(axis) @AS $MIRRORED;
*   #M155c(a) #M155d(b) %axis155(axis) @AS $MIRRORED;
*   #M155t {#M155a #M155b} @DISTANCE("bottom-to-top", min=2);
*   {#M155a #M155b} {#M155c #M155d} @DISTANCE("bottom-to-top", min=2);
*   %g156 = {#M156a #M156b #M156c #M156d #M156t} @GROUP;
*   %dp156 = #M156a(in_p) #M156b(in_n) #M156t(tail) @AS $DIFFERENTIAL_PAIR;
*   %cm156 = #M156c(ref) #M156d(out) @AS $CURRENT_MIRROR;
*   %axis156 = (_, _);
*   #M156a(a) #M156b(b) %axis156(axis) @AS $MIRRORED;
*   #M156c(a) #M156d(b) %axis156(axis) @AS $MIRRORED;
*   #M156t {#M156a #M156b} @DISTANCE("bottom-to-top", min=2);
*   {#M156a #M156b} {#M156c #M156d} @DISTANCE("bottom-to-top", min=2);
*   %g157 = {#M157a #M157b #M157c #M157d #M157t} @GROUP;
*   %dp157 = #M157a(in_p) #M157b(in_n) #M157t(tail) @AS $DIFFERENTIAL_PAIR;
*   %cm157 = #M157c(ref) #M157d(out) @AS $CURRENT_MIRROR;
*   %axis157 = (_, _);
*   #M157a(a) #M157b(b) %axis157(axis) @AS $MIRRORED;
*   #M157c(a) #M157d(b) %axis157(axis) @AS $MIRRORED;
*   #M157t {#M157a #M157b} @DISTANCE("bottom-to-top", min=2);
*   {#M157a #M157b} {#M157c #M157d} @DISTANCE("bottom-to-top", min=2);
*   %g158 = {#M158a #M158b #M158c #M158d #M158t} @GROUP;
*   %dp158 = #M158a(in_p) #M158b(in_n) #M158t(tail) @AS $DIFFERENTIAL_PAIR;
*   %cm158 = #M158c(ref) #M158d(out) @AS $CURRENT_MIRROR;
*   %axis158 = (_, _);
*   #M158a(a) #M158b(b) %axis158(axis) @AS $MIRRORED;
*   #M158c(a) #M158d(b) %axis158(axis) @AS $MIRRORED;
*   #M158t {#M158a #M158b} @DISTANCE("bottom-to-top", min=2);
*   {#M158a #M158b} {#M158c #M158d} @DISTANCE("bottom-to-top", min=2);
*   %g159 = {#M159a #M159b #M159c #M159d #M159t} @GROUP;
*   %dp159 = #M159a(in_p) #M159b(in_n) #M159t(tail) @AS $DIFFERENTIAL_PAIR;
*   %cm159 = #M159c(ref) #M159d(out) @AS $CURRENT_MIRROR;
*   %axis159 = (_, _);
*   #M159a(a) #M159b(b) %axis159(axis) @AS $MIRRORED;
*   #M159c(a) #M159d(b) %axis159(axis) @AS $MIRRORED;
*   #M159t {#M159a #M159b} @DISTANCE("bottom-to-top", min=2);
*   {#M159a #M159b} {#M159c #M159d} @DISTANCE("bottom-to-top", min=2);
*   %g160 = {#M160a #M160b #M160c #M160d #M160t} @GROUP;
*   %dp160 = #M160a(in_p) #M160b(in_n) #M160t(tail) @AS $DIFFERENTIAL_PAIR;
*   %cm160 = #M160c(ref) #M160d(out) @AS $CURRENT_MIRROR;
*   %axis160 = (_, _);
*   #M160a(a) #M160b(b) %axis160(axis) @AS $MIRRORED;
*   #M160c(a) #M160d(b) %axis160(axis) @AS $MIRRORED;
*   #M160t {#M160a #M160b} @DISTANCE("bottom-to-top", min=2);
*   {#M160a #M160b} {#M160c #M160d} @DISTANCE("bottom-to-top", min=2);
*   %g161 = {#M161a #M161b #M161c #M161d #M161t} @GROUP;
*   %dp161 = #M161a(in_p) #M161b(in_n) #M161t(tail) @AS $DIFFERENTIAL_PAIR;
*   %cm161 = #M161c(ref) #M161d(out) @AS $CURRENT_MIRROR;
*   %axis161 = (_, _);
*   #M161a(a) #M161b(b) %axis161(axis) @AS $MIRRORED;
*   #M161c(a) #M161d(b) %axis161(axis) @AS $MIRRORED;
*   #M161t {#M161a #M161b} @DISTANCE("bottom-to-top", min=2);
*   {#M161a #M161b} {#M161c #M161d} @DISTANCE("bottom-to-top", min=2);
*   %g162 = {#M162a #M162b #M162c #M162d #M162t} @GROUP;
*   %dp162 = #M162a(in_p) #M162b(in_n) #M162t(tail) @AS $DIFFERENTIAL_PAIR;
*   %cm162 = #M162c(ref) #M162d(out) @AS $CURRENT_MIRROR;
*   %axis162 = (_, _);
*   #M162a(a) #M162b(b) %axis162(axis) @AS $MIRRORED;
*   #M162c(a) #M162d(b) %axis162(axis) @AS $MIRRORED;
*   #M162t {#M162a #M162b} @DISTANCE("bottom-to-top", min=2);
*   {#M162a #M162b} {#M162c #M162d} @DISTANCE("bottom-to-top", min=2);
*   %g163 = {#M163a #M163b #M163c #M163d #M163t} @GROUP;
*   %dp163 = #M163a(in_p) #M163b(in_n) #M163t(tail) @AS $DIFFERENTIAL_PAIR;
*   %cm163 = #M163c(ref) #M163d(out) @AS $CURRENT_MIRROR;
*   %axis163 = (_, _);
*   #M163a(a) #M163b(b) %axis163(axis) @AS $MIRRORED;
*   #M163c(a) #M163d(b) %axis163(axis) @AS $MIRRORED;
*   #M163t {#M163a #M163b} @DISTANCE("bottom-to-top", min=2);
*   {#M163a #M163b} {#M163c #M163d} @DISTANCE("bottom-to-top", min=2);
*   %g164 = {#M164a #M164b #M164c #M164d #M164t} @GROUP;
*   %dp164 = #M164a(in_p) #M164b(in_n) #M164t(tail) @AS $DIFFERENTIAL_PAIR;
*   %cm164 = #M164c(ref) #M164d(out) @AS $CURRENT_MIRROR;
*   %axis164 = (_, _);
*   #M164a(a) #M164b(b) %axis164(axis) @AS $MIRRORED;
*   #M164c(a) #M164d(b) %axis164(axis) @AS $MIRRORED;
*   #M164t {#M164a #M164b} @DISTANCE("bottom-to-top", min=2);
*   {#M164a #M164b} {#M164c #M164d} @DISTANCE("bottom-to-top", min=2);
*   %g165 = {#M165a #M165b #M165c #M165d #M165t} @GROUP;
*   %dp165 = #M165a(in_p) #M165b(in_n) #M165t(tail) @AS $DIFFERENTIAL_PAIR;
*   %cm165 = #M165c(ref) #M165d(out) @AS $CURRENT_MIRROR;
*   %axis165 = (_, _);
*   #M165a(a) #M165b(b) %axis165(axis) @AS $MIRRORED;
*   #M165c(a) #M165d(b) %axis165(axis) @AS $MIRRORED;
*   #M165t {#M165a #M165b} @DISTANCE("bottom-to-top", min=2);
*   {#M165a #M165b} {#M165c #M165d} @DISTANCE("bottom-to-top", min=2);
*   %g166 = {#M166a #M166b #M166c #M166d #M166t} @GROUP;
*   %dp166 = #M166a(in_p) #M166b(in_n) #M166t(tail) @AS $DIFFERENTIAL_PAIR;
*   %cm166 = #M166c(ref) #M166d(out) @AS $CURRENT_MIRROR;
*   %axis166 = (_, _);
*   #M166a(a) #M166b(b) %axis166(axis) @AS $MIRRORED;
*   #M166c(a) #M166d(b) %axis166(axis) @AS $MIRRORED;
*   #M166t {#M166a #M166b} @DISTANCE("bottom-to-top", min=2);
*   {#M166a #M166b} {#M166c #M166d} @DISTANCE("bottom-to-top", min=2);
*   %g167 = {#M167a #M167b #M167c #M167d #M167t} @GROUP;
*   %dp167 = #M167a(in_p) #M167b(in_n) #M167t(tail) @AS $DIFFERENTIAL_PAIR;
*   %cm167 = #M167c(ref) #M167d(out) @AS $CURRENT_MIRROR;
*   %axis167 = (_, _);
*   #M167a(a) #M167b(b) %axis167(axis) @AS $MIRRORED;
*   #M167c(a) #M167d(b) %axis167(axis) @AS $MIRRORED;
*   #M167t {#M167a #M167b} @DISTANCE("bottom-to-top", min=2);
*   {#M167a #M167b} {#M167c #M167d} @DISTANCE("bottom-to-top", min=2);
*   %g168 = {#M168a #M168b #M168c #M168d #M168t} @GROUP;
*   %dp168 = #M168a(in_p) #M168b(in_n) #M168t(tail) @AS $DIFFERENTIAL_PAIR;
*   %cm168 = #M168c(ref) #M168d(out) @AS $CURRENT_MIRROR;
*   %axis168 = (_, _);
*   #M168a(a) #M168b(b) %axis168(axis) @AS $MIRRORED;
*   #M168c(a) #M168d(b) %axis168(axis) @AS $MIRRORED;
*   #M168t {#M168a #M168b} @DISTANCE("bottom-to-top", min=2);
*   {#M168a #M168b} {#M168c #M168d} @DISTANCE("bottom-to-top", min=2);
*   %g169 = {#M169a #M169b #M169c #M169d #M169t} @GROUP;
*   %dp169 = #M169a(in_p) #M169b(in_n) #M169t(tail) @AS $DIFFERENTIAL_PAIR;
*   %cm169 = #M169c(ref) #M169d(out) @AS $CURRENT_MIRROR;
*   %axis169 = (_, _);
*   #M169a(a) #M169b(b) %axis169(axis) @AS $MIRRORED;
*   #M169c(a) #M169d(b) %axis169(axis) @AS $MIRRORED;
*   #M169t {#M169a #M169b} @DISTANCE("bottom-to-top", min=2);
*   {#M169a #M169b} {#M169c #M169d} @DISTANCE("bottom-to-top", min=2);
*   %g170 = {#M170a #M170b #M170c #M170d #M170t} @GROUP;
*   %dp170 = #M170a(in_p) #M170b(in_n) #M170t(tail) @AS $DIFFERENTIAL_PAIR;
*   %cm170 = #M170c(ref) #M170d(out) @AS $CURRENT_MIRROR;
*   %axis170 = (_, _);
*   #M170a(a) #M170b(b) %axis170(axis) @AS $MIRRORED;
*   #M170c(a) #M170d(b) %axis170(axis) @AS $MIRRORED;
*   #M170t {#M170a #M170b} @DISTANCE("bottom-to-top", min=2);
*   {#M170a #M170b} {#M170c #M170d} @DISTANCE("bottom-to-top", min=2);
*   %g171 = {#M171a #M171b #M171c #M171d #M171t} @GROUP;
*   %dp171 = #M171a(in_p) #M171b(in_n) #M171t(tail) @AS $DIFFERENTIAL_PAIR;
*   %cm171 = #M171c(ref) #M171d(out) @AS $CURRENT_MIRROR;
*   %axis171 = (_, _);
*   #M171a(a) #M171b(b) %axis171(axis) @AS $MIRRORED;
*   #M171c(a) #M171d(b) %axis171(axis) @AS $MIRRORED;
*   #M171t {#M171a #M171b} @DISTANCE("bottom-to-top", min=2);
*   {#M171a #M171b} {#M171c #M171d} @DISTANCE("bottom-to-top", min=2);
*   %g172 = {#M172a #M172b #M172c #M172d #M172t} @GROUP;
*   %dp172 = #M172a(in_p) #M172b(in_n) #M172t(tail) @AS $DIFFERENTIAL_PAIR;
*   %cm172 = #M172c(ref) #M172d(out) @AS $CURRENT_MIRROR;
*   %axis172 = (_, _);
*   #M172a(a) #M172b(b) %axis172(axis) @AS $MIRRORED;
*   #M172c(a) #M172d(b) %axis172(axis) @AS $MIRRORED;
*   #M172t {#M172a #M172b} @DISTANCE("bottom-to-top", min=2);
*   {#M172a #M172b} {#M172c #M172d} @DISTANCE("bottom-to-top", min=2);
*   %g173 = {#M173a #M173b #M173c #M173d #M173t} @GROUP;
*   %dp173 = #M173a(in_p) #M173b(in_n) #M173t(tail) @AS $DIFFERENTIAL_PAIR;
*   %cm173 = #M173c(ref) #M173d(out) @AS $CURRENT_MIRROR;
*   %axis173 = (_, _);
*   #M173a(a) #M173b(b) %axis173(axis) @AS $MIRRORED;
*   #M173c(a) #M173d(b) %axis173(axis) @AS $MIRRORED;
*   #M173t {#M173a #M173b} @DISTANCE("bottom-to-top", min=2);
*   {#M173a #M173b} {#M173c #M173d} @DISTANCE("bottom-to-top", min=2);
*   %g174 = {#M174a #M174b #M174c #M174d #M174t} @GROUP;
*   %dp174 = #M174a(in_p) #M174b(in_n) #M174t(tail) @AS $DIFFERENTIAL_PAIR;
*   %cm174 = #M174c(ref) #M174d(out) @AS $CURRENT_MIRROR;
*   %axis174 = (_, _);
*   #M174a(a) #M174b(b) %axis174(axis) @AS $MIRRORED;
*   #M174c(a) #M174d(b) %axis174(axis) @AS $MIRRORED;
*   #M174t {#M174a #M174b} @DISTANCE("bottom-to-top", min=2);
*   {#M174a #M174b} {#M174c #M174d} @DISTANCE("bottom-to-top", min=2);
*   %g175 = {#M175a #M175b #M175c #M175d #M175t} @GROUP;
*   %dp175 = #M175a(in_p) #M175b(in_n) #M175t(tail) @AS $DIFFERENTIAL_PAIR;
*   %cm175 = #M175c(ref) #M175d(out) @AS $CURRENT_MIRROR;
*   %axis175 = (_, _);
*   #M175a(a) #M175b(b) %axis175(axis) @AS $MIRRORED;
*   #M175c(a) #M175d(b) %axis175(axis) @AS $MIRRORED;
*   #M175t {#M175a #M175b} @DISTANCE("bottom-to-top", min=2);
*   {#M175a #M175b} {#M175c #M175d} @DISTANCE("bottom-to-top", min=2);
*   %g176 = {#M176a #M176b #M176c #M176d #M176t} @GROUP;
*   %dp176 = #M176a(in_p) #M176b(in_n) #M176t(tail) @AS $DIFFERENTIAL_PAIR;
*   %cm176 = #M176c(ref) #M176d(out) @AS $CURRENT_MIRROR;
*   %axis176 = (_, _);
*   #M176a(a) #M176b(b) %axis176(axis) @AS $MIRRORED;
*   #M176c(a) #M176d(b) %axis176(axis) @AS $MIRRORED;
*   #M176t {#M176a #M176b} @DISTANCE("bottom-to-top", min=2);
*   {#M176a #M176b} {#M176c #M176d} @DISTANCE("bottom-to-top", min=2);
*   %g177 = {#M177a #M177b #M177c #M177d #M177t} @GROUP;
*   %dp177 = #M177a(in_p) #M177b(in_n) #M177t(tail) @AS $DIFFERENTIAL_PAIR;
*   %cm177 = #M177c(ref) #M177d(out) @AS $CURRENT_MIRROR;
*   %axis177 = (_, _);
*   #M177a(a) #M177b(b) %axis177(axis) @AS $MIRRORED;
*   #M177c(a) #M177d(b) %axis177(axis) @AS $MIRRORED;
*   #M177t {#M177a #M177b} @DISTANCE("bottom-to-top", min=2);
*   {#M177a #M177b} {#M177c #M177d} @DISTANCE("bottom-to-top", min=2);
*   %g178 = {#M178a #M178b #M178c #M178d #M178t} @GROUP;
*   %dp178 = #M178a(in_p) #M178b(in_n) #M178t(tail) @AS $DIFFERENTIAL_PAIR;
*   %cm178 = #M178c(ref) #M178d(out) @AS $CURRENT_MIRROR;
*   %axis178 = (_, _);
*   #M178a(a) #M178b(b) %axis178(axis) @AS $MIRRORED;
*   #M178c(a) #M178d(b) %axis178(axis) @AS $MIRRORED;
*   #M178t {#M178a #M178b} @DISTANCE("bottom-to-top", min=2);
*   {#M178a #M178b} {#M178c #M178d} @DISTANCE("bottom-to-top", min=2);
*   %g179 = {#M179a #M179b #M179c #M179d #M179t} @GROUP;
*   %dp179 = #M179a(in_p) #M179b(in_n) #M179t(tail) @AS $DIFFERENTIAL_PAIR;
*   %cm179 = #M179c(ref) #M179d(out) @AS $CURRENT_MIRROR;
*   %axis179 = (_, _);
*   #M179a(a) #M179b(b) %axis179(axis) @AS $MIRRORED;
*   #M179c(a) #M179d(b) %axis179(axis) @AS $MIRRORED;
*   #M179t {#M179a #M179b} @DISTANCE("bottom-to-top", min=2);
*   {#M179a #M179b} {#M179c #M179d} @DISTANCE("bottom-to-top", min=2);
*   %g180 = {#M180a #M180b #M180c #M180d #M180t} @GROUP;
*   %dp180 = #M180a(in_p) #M180b(in_n) #M180t(tail) @AS $DIFFERENTIAL_PAIR;
*   %cm180 = #M180c(ref) #M180d(out) @AS $CURRENT_MIRROR;
*   %axis180 = (_, _);
*   #M180a(a) #M180b(b) %axis180(axis) @AS $MIRRORED;
*   #M180c(a) #M180d(b) %axis180(axis) @AS $MIRRORED;
*   #M180t {#M180a #M180b} @DISTANCE("bottom-to-top", min=2);
*   {#M180a #M180b} {#M180c #M180d} @DISTANCE("bottom-to-top", min=2);
*   %g181 = {#M181a #M181b #M181c #M181d #M181t} @GROUP;
*   %dp181 = #M181a(in_p) #M181b(in_n) #M181t(tail) @AS $DIFFERENTIAL_PAIR;
*   %cm181 = #M181c(ref) #M181d(out) @AS $CURRENT_MIRROR;
*   %axis181 = (_, _);
*   #M181a(a) #M181b(b) %axis181(axis) @AS $MIRRORED;
*   #M181c(a) #M181d(b) %axis181(axis) @AS $MIRRORED;
*   #M181t {#M181a #M181b} @DISTANCE("bottom-to-top", min=2);
*   {#M181a #M181b} {#M181c #M181d} @DISTANCE("bottom-to-top", min=2);
*   %g182 = {#M182a #M182b #M182c #M182d #M182t} @GROUP;
*   %dp182 = #M182a(in_p) #M182b(in_n) #M182t(tail) @AS $DIFFERENTIAL_PAIR;
*   %cm182 = #M182c(ref) #M182d(out) @AS $CURRENT_MIRROR;
*   %axis182 = (_, _);
*   #M182a(a) #M182b(b) %axis182(axis) @AS $MIRRORED;
*   #M182c(a) #M182d(b) %axis182(axis) @AS $MIRRORED;
*   #M182t {#M182a #M182b} @DISTANCE("bottom-to-top", min=2);
*   {#M182a #M182b} {#M182c #M182d} @DISTANCE("bottom-to-top", min=2);
*   %g183 = {#M183a #M183b #M183c #M183d #M183t} @GROUP;
*   %dp183 = #M183a(in_p) #M183b(in_n) #M183t(tail) @AS $DIFFERENTIAL_PAIR;
*   %cm183 = #M183c(ref) #M183d(out) @AS $CURRENT_MIRROR;
*   %axis183 = (_, _);
*   #M183a(a) #M183b(b) %axis183(axis) @AS $MIRRORED;
*   #M183c(a) #M183d(b) %axis183(axis) @AS $MIRRORED;
*   #M183t {#M183a #M183b} @DISTANCE("bottom-to-top", min=2);
*   {#M183a #M183b} {#M183c #M183d} @DISTANCE("bottom-to-top", min=2);
*   %g184 = {#M184a #M184b #M184c #M184d #M184t} @GROUP;
*   %dp184 = #M184a(in_p) #M184b(in_n) #M184t(tail) @AS $DIFFERENTIAL_PAIR;
*   %cm184 = #M184c(ref) #M184d(out) @AS $CURRENT_MIRROR;
*   %axis184 = (_, _);
*   #M184a(a) #M184b(b) %axis184(axis) @AS $MIRRORED;
*   #M184c(a) #M184d(b) %axis184(axis) @AS $MIRRORED;
*   #M184t {#M184a #M184b} @DISTANCE("bottom-to-top", min=2);
*   {#M184a #M184b} {#M184c #M184d} @DISTANCE("bottom-to-top", min=2);
*   %g185 = {#M185a #M185b #M185c #M185d #M185t} @GROUP;
*   %dp185 = #M185a(in_p) #M185b(in_n) #M185t(tail) @AS $DIFFERENTIAL_PAIR;
*   %cm185 = #M185c(ref) #M185d(out) @AS $CURRENT_MIRROR;
*   %axis185 = (_, _);
*   #M185a(a) #M185b(b) %axis185(axis) @AS $MIRRORED;
*   #M185c(a) #M185d(b) %axis185(axis) @AS $MIRRORED;
*   #M185t {#M185a #M185b} @DISTANCE("bottom-to-top", min=2);
*   {#M185a #M185b} {#M185c #M185d} @DISTANCE("bottom-to-top", min=2);
*   %g186 = {#M186a #M186b #M186c #M186d #M186t} @GROUP;
*   %dp186 = #M186a(in_p) #M186b(in_n) #M186t(tail) @AS $DIFFERENTIAL_PAIR;
*   %cm186 = #M186c(ref) #M186d(out) @AS $CURRENT_MIRROR;
*   %axis186 = (_, _);
*   #M186a(a) #M186b(b) %axis186(axis) @AS $MIRRORED;
*   #M186c(a) #M186d(b) %axis186(axis) @AS $MIRRORED;
*   #M186t {#M186a #M186b} @DISTANCE("bottom-to-top", min=2);
*   {#M186a #M186b} {#M186c #M186d} @DISTANCE("bottom-to-top", min=2);
*   %g187 = {#M187a #M187b #M187c #M187d #M187t} @GROUP;
*   %dp187 = #M187a(in_p) #M187b(in_n) #M187t(tail) @AS $DIFFERENTIAL_PAIR;
*   %cm187 = #M187c(ref) #M187d(out) @AS $CURRENT_MIRROR;
*   %axis187 = (_, _);
*   #M187a(a) #M187b(b) %axis187(axis) @AS $MIRRORED;
*   #M187c(a) #M187d(b) %axis187(axis) @AS $MIRRORED;
*   #M187t {#M187a #M187b} @DISTANCE("bottom-to-top", min=2);
*   {#M187a #M187b} {#M187c #M187d} @DISTANCE("bottom-to-top", min=2);
*   %g188 = {#M188a #M188b #M188c #M188d #M188t} @GROUP;
*   %dp188 = #M188a(in_p) #M188b(in_n) #M188t(tail) @AS $DIFFERENTIAL_PAIR;
*   %cm188 = #M188c(ref) #M188d(out) @AS $CURRENT_MIRROR;
*   %axis188 = (_, _);
*   #M188a(a) #M188b(b) %axis188(axis) @AS $MIRRORED;
*   #M188c(a) #M188d(b) %axis188(axis) @AS $MIRRORED;
*   #M188t {#M188a #M188b} @DISTANCE("bottom-to-top", min=2);
*   {#M188a #M188b} {#M188c #M188d} @DISTANCE("bottom-to-top", min=2);
*   %g189 = {#M189a #M189b #M189c #M189d #M189t} @GROUP;
*   %dp189 = #M189a(in_p) #M189b(in_n) #M189t(tail) @AS $DIFFERENTIAL_PAIR;
*   %cm189 = #M189c(ref) #M189d(out) @AS $CURRENT_MIRROR;
*   %axis189 = (_, _);
*   #M189a(a) #M189b(b) %axis189(axis) @AS $MIRRORED;
*   #M189c(a) #M189d(b) %axis189(axis) @AS $MIRRORED;
*   #M189t {#M189a #M189b} @DISTANCE("bottom-to-top", min=2);
*   {#M189a #M189b} {#M189c #M189d} @DISTANCE("bottom-to-top", min=2);
*   %g190 = {#M190a #M190b #M190c #M190d #M190t} @GROUP;
*   %dp190 = #M190a(in_p) #M190b(in_n) #M190t(tail) @AS $DIFFERENTIAL_PAIR;
*   %cm190 = #M190c(ref) #M190d(out) @AS $CURRENT_MIRROR;
*   %axis190 = (_, _);
*   #M190a(a) #M190b(b) %axis190(axis) @AS $MIRRORED;
*   #M190c(a) #M190d(b) %axis190(axis) @AS $MIRRORED;
*   #M190t {#M190a #M190b} @DISTANCE("bottom-to-top", min=2);
*   {#M190a #M190b} {#M190c #M190d} @DISTANCE("bottom-to-top", min=2);
*   %g191 = {#M191a #M191b #M191c #M191d #M191t} @GROUP;
*   %dp191 = #M191a(in_p) #M191b(in_n) #M191t(tail) @AS $DIFFERENTIAL_PAIR;
*   %cm191 = #M191c(ref) #M191d(out) @AS $CURRENT_MIRROR;
*   %axis191 = (_, _);
*   #M191a(a) #M191b(b) %axis191(axis) @AS $MIRRORED;
*   #M191c(a) #M191d(b) %axis191(axis) @AS $MIRRORED;
*   #M191t {#M191a #M191b} @DISTANCE("bottom-to-top", min=2);
*   {#M191a #M191b} {#M191c #M191d} @DISTANCE("bottom-to-top", min=2);
*   %g192 = {#M192a #M192b #M192c #M192d #M192t} @GROUP;
*   %dp192 = #M192a(in_p) #M192b(in_n) #M192t(tail) @AS $DIFFERENTIAL_PAIR;
*   %cm192 = #M192c(ref) #M192d(out) @AS $CURRENT_MIRROR;
*   %axis192 = (_, _);
*   #M192a(a) #M192b(b) %axis192(axis) @AS $MIRRORED;
*   #M192c(a) #M192d(b) %axis192(axis) @AS $MIRRORED;
*   #M192t {#M192a #M192b} @DISTANCE("bottom-to-top", min=2);
*   {#M192a #M192b} {#M192c #M192d} @DISTANCE("bottom-to-top", min=2);
*   %g193 = {#M193a #M193b #M193c #M193d #M193t} @GROUP;
*   %dp193 = #M193a(in_p) #M193b(in_n) #M193t(tail) @AS $DIFFERENTIAL_PAIR;
*   %cm193 = #M193c(ref) #M193d(out) @AS $CURRENT_MIRROR;
*   %axis193 = (_, _);
*   #M193a(a) #M193b(b) %axis193(axis) @AS $MIRRORED;
*   #M193c(a) #M193d(b) %axis193(axis) @AS $MIRRORED;
*   #M193t {#M193a #M193b} @DISTANCE("bottom-to-top", min=2);
*   {#M193a #M193b} {#M193c #M193d} @DISTANCE("bottom-to-top", min=2);
*   %g194 = {#M194a #M194b #M194c #M194d #M194t} @GROUP;
*   %dp194 = #M194a(in_p) #M194b(in_n) #M194t(tail) @AS $DIFFERENTIAL_PAIR;
*   %cm194 = #M194c(ref) #M194d(out) @AS $CURRENT_MIRROR;
*   %axis194 = (_, _);
*   #M194a(a) #M194b(b) %axis194(axis) @AS $MIRRORED;
*   #M194c(a) #M194d(b) %axis194(axis) @AS $MIRRORED;
*   #M194t {#M194a #M194b} @DISTANCE("bottom-to-top", min=2);
*   {#M194a #M194b} {#M194c #M194d} @DISTANCE("bottom-to-top", min=2);
*   %g195 = {#M195a #M195b #M195c #M195d #M195t} @GROUP;
*   %dp195 = #M195a(in_p) #M195b(in_n) #M195t(tail) @AS $DIFFERENTIAL_PAIR;
*   %cm195 = #M195c(ref) #M195d(out) @AS $CURRENT_MIRROR;
*   %axis195 = (_, _);
*   #M195a(a) #M195b(b) %axis195(axis) @AS $MIRRORED;
*   #M195c(a) #M195d(b) %axis195(axis) @AS $MIRRORED;
*   #M195t {#M195a #M195b} @DISTANCE("bottom-to-top", min=2);
*   {#M195a #M195b} {#M195c #M195d} @DISTANCE("bottom-to-top", min=2);
*   %g196 = {#M196a #M196b #M196c #M196d #M196t} @GROUP;
*   %dp196 = #M196a(in_p) #M196b(in_n) #M196t(tail) @AS $DIFFERENTIAL_PAIR;
*   %cm196 = #M196c(ref) #M196d(out) @AS $CURRENT_MIRROR;
*   %axis196 = (_, _);
*   #M196a(a) #M196b(b) %axis196(axis) @AS $MIRRORED;
*   #M196c(a) #M196d(b) %axis196(axis) @AS $MIRRORED;
*   #M196t {#M196a #M196b} @DISTANCE("bottom-to-top", min=2);
*   {#M196a #M196b} {#M196c #M196d} @DISTANCE("bottom-to-top", min=2);
*   %g197 = {#M197a #M197b #M197c #M197d #M197t} @GROUP;
*   %dp197 = #M197a(in_p) #M197b(in_n) #M197t(tail) @AS $DIFFERENTIAL_PAIR;
*   %cm197 = #M197c(ref) #M197d(out) @AS $CURRENT_MIRROR;
*   %axis197 = (_, _);
*   #M197a(a) #M197b(b) %axis197(axis) @AS $MIRRORED;
*   #M197c(a) #M197d(b) %axis197(axis) @AS $MIRRORED;
*   #M197t {#M197a #M197b} @DISTANCE("bottom-to-top", min=2);
*   {#M197a #M197b} {#M197c #M197d} @DISTANCE("bottom-to-top", min=2);
*   %g198 = {#M198a #M198b #M198c #M198d #M198t} @GROUP;
*   %dp198 = #M198a(in_p) #M198b(in_n) #M198t(tail) @AS $DIFFERENTIAL_PAIR;
*   %cm198 = #M198c(ref) #M198d(out) @AS $CURRENT_MIRROR;
*   %axis198 = (_, _);
*   #M198a(a) #M198b(b) %axis198(axis) @AS $MIRRORED;
*   #M198c(a) #M198d(b) %axis198(axis) @AS $MIRRORED;
*   #M198t {#M198a #M198b} @DISTANCE("bottom-to-top", min=2);
*   {#M198a #M198b} {#M198c #M198d} @DISTANCE("bottom-to-top", min=2);
*   %g199 = {#M199a #M199b #M199c #M199d #M199t} @GROUP;
*   %dp199 = #M199a(in_p) #M199b(in_n) #M199t(tail) @AS $DIFFERENTIAL_PAIR;
*   %cm199 = #M199c(ref) #M199d(out) @AS $CURRENT_MIRROR;
*   %axis199 = (_, _);
*   #M199a(a) #M199b(b) %axis199(axis) @AS $MIRRORED;
*   #M199c(a) #M199d(b) %axis199(axis) @AS $MIRRORED;
*   #M199t {#M199a #M199b} @DISTANCE("bottom-to-top", min=2);
*   {#M199a #M199b} {#M199c #M199d} @DISTANCE("bottom-to-top", min=2);
*   %g200 = {#M200a #M200b #M200c #M200d #M200t} @GROUP;
*   %dp200 = #M200a(in_p) #M200b(in_n) #M200t(tail) @AS $DIFFERENTIAL_PAIR;
*   %cm200 = #M200c(ref) #M200d(out) @AS $CURRENT_MIRROR;
*   %axis200 = (_, _);
*   #M200a(a) #M200b(b) %axis200(axis) @AS $MIRRORED;
*   #M200c(a) #M200d(b) %axis200(axis) @AS $MIRRORED;
*   #M200t {#M200a #M200b} @DISTANCE("bottom-to-top", min=2);
*   {#M200a #M200b} {#M200c #M200d} @DISTANCE("bottom-to-top", min=2);
*   %g201 = {#M201a #M201b #M201c #M201d #M201t} @GROUP;
*   %dp201 = #M201a(in_p) #M201b(in_n) #M201t(tail) @AS $DIFFERENTIAL_PAIR;
*   %cm201 = #M201c(ref) #M201d(out) @AS $CURRENT_MIRROR;
*   %axis201 = (_, _);
*   #M201a(a) #M201b(b) %axis201(axis) @AS $MIRRORED;
*   #M201c(a) #M201d(b) %axis201(axis) @AS $MIRRORED;
*   #M201t {#M201a #M201b} @DISTANCE("bottom-to-top", min=2);
*   {#M201a #M201b} {#M201c #M201d} @DISTANCE("bottom-to-top", min=2);
*   %g202 = {#M202a #M202b #M202c #M202d #M202t} @GROUP;
*   %dp202 = #M202a(in_p) #M202b(in_n) #M202t(tail) @AS $DIFFERENTIAL_PAIR;
*   %cm202 = #M202c(ref) #M202d(out) @AS $CURRENT_MIRROR;
*   %axis202 = (_, _);
*   #M202a(a) #M202b(b) %axis202(axis) @AS $MIRRORED;
*   #M202c(a) #M202d(b) %axis202(axis) @AS $MIRRORED;
*   #M202t {#M202a #M202b} @DISTANCE("bottom-to-top", min=2);
*   {#M202a #M202b} {#M202c #M202d} @DISTANCE("bottom-to-top", min=2);
*   %g203 = {#M203a #M203b #M203c #M203d #M203t} @GROUP;
*   %dp203 = #M203a(in_p) #M203b(in_n) #M203t(tail) @AS $DIFFERENTIAL_PAIR;
*   %cm203 = #M203c(ref) #M203d(out) @AS $CURRENT_MIRROR;
*   %axis203 = (_, _);
*   #M203a(a) #M203b(b) %axis203(axis) @AS $MIRRORED;
*   #M203c(a) #M203d(b) %axis203(axis) @AS $MIRRORED;
*   #M203t {#M203a #M203b} @DISTANCE("bottom-to-top", min=2);
*   {#M203a #M203b} {#M203c #M203d} @DISTANCE("bottom-to-top", min=2);
*   %g204 = {#M204a #M204b #M204c #M204d #M204t} @GROUP;
*   %dp204 = #M204a(in_p) #M204b(in_n) #M204t(tail) @AS $DIFFERENTIAL_PAIR;
*   %cm204 = #M204c(ref) #M204d(out) @AS $CURRENT_MIRROR;
*   %axis204 = (_, _);
*   #M204a(a) #M204b(b) %axis204(axis) @AS $MIRRORED;
*   #M204c(a) #M204d(b) %axis204(axis) @AS $MIRRORED;
*   #M204t {#M204a #M204b} @DISTANCE("bottom-to-top", min=2);
*   {#M204a #M204b} {#M204c #M204d} @DISTANCE("bottom-to-top", min=2);
*   %g205 = {#M205a #M205b #M205c #M205d #M205t} @GROUP;
*   %dp205 = #M205a(in_p) #M205b(in_n) #M205t(tail) @AS $DIFFERENTIAL_PAIR;
*   %cm205 = #M205c(ref) #M205d(out) @AS $CURRENT_MIRROR;
*   %axis205 = (_, _);
*   #M205a(a) #M205b(b) %axis205(axis) @AS $MIRRORED;
*   #M205c(a) #M205d(b) %axis205(axis) @AS $MIRRORED;
*   #M205t {#M205a #M205b} @DISTANCE("bottom-to-top", min=2);
*   {#M205a #M205b} {#M205c #M205d} @DISTANCE("bottom-to-top", min=2);
*   %g206 = {#M206a #M206b #M206c #M206d #M206t} @GROUP;
*   %dp206 = #M206a(in_p) #M206b(in_n) #M206t(tail) @AS $DIFFERENTIAL_PAIR;
*   %cm206 = #M206c(ref) #M206d(out) @AS $CURRENT_MIRROR;
*   %axis206 = (_, _);
*   #M206a(a) #M206b(b) %axis206(axis) @AS $MIRRORED;
*   #M206c(a) #M206d(b) %axis206(axis) @AS $MIRRORED;
*   #M206t {#M206a #M206b} @DISTANCE("bottom-to-top", min=2);
*   {#M206a #M206b} {#M206c #M206d} @DISTANCE("bottom-to-top", min=2);
*   %g207 = {#M207a #M207b #M207c #M207d #M207t} @GROUP;
*   %dp207 = #M207a(in_p) #M207b(in_n) #M207t(tail) @AS $DIFFERENTIAL_PAIR;
*   %cm207 = #M207c(ref) #M207d(out) @AS $CURRENT_MIRROR;
*   %axis207 = (_, _);
*   #M207a(a) #M207b(b) %axis207(axis) @AS $MIRRORED;
*   #M207c(a) #M207d(b) %axis207(axis) @AS $MIRRORED;
*   #M207t {#M207a #M207b} @DISTANCE("bottom-to-top", min=2);
*   {#M207a #M207b} {#M207c #M207d} @DISTANCE("bottom-to-top", min=2);
*   %g208 = {#M208a #M208b #M208c #M208d #M208t} @GROUP;
*   %dp208 = #M208a(in_p) #M208b(in_n) #M208t(tail) @AS $DIFFERENTIAL_PAIR;
*   %cm208 = #M208c(ref) #M208d(out) @AS $CURRENT_MIRROR;
*   %axis208 = (_, _);
*   #M208a(a) #M208b(b) %axis208(axis) @AS $MIRRORED;
*   #M208c(a) #M208d(b) %axis208(axis) @AS $MIRRORED;
*   #M208t {#M208a #M208b} @DISTANCE("bottom-to-top", min=2);
*   {#M208a #M208b} {#M208c #M208d} @DISTANCE("bottom-to-top", min=2);
*   %g209 = {#M209a #M209b #M209c #M209d #M209t} @GROUP;
*   %dp209 = #M209a(in_p) #M209b(in_n) #M209t(tail) @AS $DIFFERENTIAL_PAIR;
*   %cm209 = #M209c(ref) #M209d(out) @AS $CURRENT_MIRROR;
*   %axis209 = (_, _);
*   #M209a(a) #M209b(b) %axis209(axis) @AS $MIRRORED;
*   #M209c(a) #M209d(b) %axis209(axis) @AS $MIRRORED;
*   #M209t {#M209a #M209b} @DISTANCE("bottom-to-top", min=2);
*   {#M209a #M209b} {#M209c #M209d} @DISTANCE("bottom-to-top", min=2);
*   %g210 = {#M210a #M210b #M210c #M210d #M210t} @GROUP;
*   %dp210 = #M210a(in_p) #M210b(in_n) #M210t(tail) @AS $DIFFERENTIAL_PAIR;
*   %cm210 = #M210c(ref) #M210d(out) @AS $CURRENT_MIRROR;
*   %axis210 = (_, _);
*   #M210a(a) #M210b(b) %axis210(axis) @AS $MIRRORED;
*   #M210c(a) #M210d(b) %axis210(axis) @AS $MIRRORED;
*   #M210t {#M210a #M210b} @DISTANCE("bottom-to-top", min=2);
*   {#M210a #M210b} {#M210c #M210d} @DISTANCE("bottom-to-top", min=2);
*   %g211 = {#M211a #M211b #M211c #M211d #M211t} @GROUP;
*   %dp211 = #M211a(in_p) #M211b(in_n) #M211t(tail) @AS $DIFFERENTIAL_PAIR;
*   %cm211 = #M211c(ref) #M211d(out) @AS $CURRENT_MIRROR;
*   %axis211 = (_, _);
*   #M211a(a) #M211b(b) %axis211(axis) @AS $MIRRORED;
*   #M211c(a) #M211d(b) %axis211(axis) @AS $MIRRORED;
*   #M211t {#M211a #M211b} @DISTANCE("bottom-to-top", min=2);
*   {#M211a #M211b} {#M211c #M211d} @DISTANCE("bottom-to-top", min=2);
*   %g212 = {#M212a #M212b #M212c #M212d #M212t} @GROUP;
*   %dp212 = #M212a(in_p) #M212b(in_n) #M212t(tail) @AS $DIFFERENTIAL_PAIR;
*   %cm212 = #M212c(ref) #M212d(out) @AS $CURRENT_MIRROR;
*   %axis212 = (_, _);
*   #M212a(a) #M212b(b) %axis212(axis) @AS $MIRRORED;
*   #M212c(a) #M212d(b) %axis212(axis) @AS $MIRRORED;
*   #M212t {#M212a #M212b} @DISTANCE("bottom-to-top", min=2);
*   {#M212a #M212b} {#M212c #M212d} @DISTANCE("bottom-to-top", min=2);
*   %g213 = {#M213a #M213b #M213c #M213d #M213t} @GROUP;
*   %dp213 = #M213a(in_p) #M213b(in_n) #M213t(tail) @AS $DIFFERENTIAL_PAIR;
*   %cm213 = #M213c(ref) #M213d(out) @AS $CURRENT_MIRROR;
*   %axis213 = (_, _);
*   #M213a(a) #M213b(b) %axis213(axis) @AS $MIRRORED;
*   #M213c(a) #M213d(b) %axis213(axis) @AS $MIRRORED;
*   #M213t {#M213a #M213b} @DISTANCE("bottom-to-top", min=2);
*   {#M213a #M213b} {#M213c #M213d} @DISTANCE("bottom-to-top", min=2);
*   %g214 = {#M214a #M214b #M214c #M214d #M214t} @GROUP;
*   %dp214 = #M214a(in_p) #M214b(in_n) #M214t(tail) @AS $DIFFERENTIAL_PAIR;
*   %cm214 = #M214c(ref) #M214d(out) @AS $CURRENT_MIRROR;
*   %axis214 = (_, _);
*   #M214a(a) #M214b(b) %axis214(axis) @AS $MIRRORED;
*   #M214c(a) #M214d(b) %axis214(axis) @AS $MIRRORED;
*   #M214t {#M214a #M214b} @DISTANCE("bottom-to-top", min=2);
*   {#M214a #M214b} {#M214c #M214d} @DISTANCE("bottom-to-top", min=2);
*   %g215 = {#M215a #M215b #M215c #M215d #M215t} @GROUP;
*   %dp215 = #M215a(in_p) #M215b(in_n) #M215t(tail) @AS $DIFFERENTIAL_PAIR;
*   %cm215 = #M215c(ref) #M215d(out) @AS $CURRENT_MIRROR;
*   %axis215 = (_, _);
*   #M215a(a) #M215b(b) %axis215(axis) @AS $MIRRORED;
*   #M215c(a) #M215d(b) %axis215(axis) @AS $MIRRORED;
*   #M215t {#M215a #M215b} @DISTANCE("bottom-to-top", min=2);
*   {#M215a #M215b} {#M215c #M215d} @DISTANCE("bottom-to-top", min=2);
*   %g216 = {#M216a #M216b #M216c #M216d #M216t} @GROUP;
*   %dp216 = #M216a(in_p) #M216b(in_n) #M216t(tail) @AS $DIFFERENTIAL_PAIR;
*   %cm216 = #M216c(ref) #M216d(out) @AS $CURRENT_MIRROR;
*   %axis216 = (_, _);
*   #M216a(a) #M216b(b) %axis216(axis) @AS $MIRRORED;
*   #M216c(a) #M216d(b) %axis216(axis) @AS $MIRRORED;
*   #M216t {#M216a #M216b} @DISTANCE("bottom-to-top", min=2);
*   {#M216a #M216b} {#M216c #M216d} @DISTANCE("bottom-to-top", min=2);
*   %g217 = {#M217a #M217b #M217c #M217d #M217t} @GROUP;
*   %dp217 = #M217a(in_p) #M217b(in_n) #M217t(tail) @AS $DIFFERENTIAL_PAIR;
*   %cm217 = #M217c(ref) #M217d(out) @AS $CURRENT_MIRROR;
*   %axis217 = (_, _);
*   #M217a(a) #M217b(b) %axis217(axis) @AS $MIRRORED;
*   #M217c(a) #M217d(b) %axis217(axis) @AS $MIRRORED;
*   #M217t {#M217a #M217b} @DISTANCE("bottom-to-top", min=2);
*   {#M217a #M217b} {#M217c #M217d} @DISTANCE("bottom-to-top", min=2);
*   %g218 = {#M218a #M218b #M218c #M218d #M218t} @GROUP;
*   %dp218 = #M218a(in_p) #M218b(in_n) #M218t(tail) @AS $DIFFERENTIAL_PAIR;
*   %cm218 = #M218c(ref) #M218d(out) @AS $CURRENT_MIRROR;
*   %axis218 = (_, _);
*   #M218a(a) #M218b(b) %axis218(axis) @AS $MIRRORED;
*   #M218c(a) #M218d(b) %axis218(axis) @AS $MIRRORED;
*   #M218t {#M218a #M218b} @DISTANCE("bottom-to-top", min=2);
*   {#M218a #M218b} {#M218c #M218d} @DISTANCE("bottom-to-top", min=2);
*   %g219 = {#M219a #M219b #M219c #M219d #M219t} @GROUP;
*   %dp219 = #M219a(in_p) #M219b(in_n) #M219t(tail) @AS $DIFFERENTIAL_PAIR;
*   %cm219 = #M219c(ref) #M219d(out) @AS $CURRENT_MIRROR;
*   %axis219 = (_, _);
*   #M219a(a) #M219b(b) %axis219(axis) @AS $MIRRORED;
*   #M219c(a) #M219d(b) %axis219(axis) @AS $MIRRORED;
*   #M219t {#M219a #M219b} @DISTANCE("bottom-to-top", min=2);
*   {#M219a #M219b} {#M219c #M219d} @DISTANCE("bottom-to-top", min=2);
*   %g220 = {#M220a #M220b #M220c #M220d #M220t} @GROUP;
*   %dp220 = #M220a(in_p) #M220b(in_n) #M220t(tail) @AS $DIFFERENTIAL_PAIR;
*   %cm220 = #M220c(ref) #M220d(out) @AS $CURRENT_MIRROR;
*   %axis220 = (_, _);
*   #M220a(a) #M220b(b) %axis220(axis) @AS $MIRRORED;
*   #M220c(a) #M220d(b) %axis220(axis) @AS $MIRRORED;
*   #M220t {#M220a #M220b} @DISTANCE("bottom-to-top", min=2);
*   {#M220a #M220b} {#M220c #M220d} @DISTANCE("bottom-to-top", min=2);
*   %g221 = {#M221a #M221b #M221c #M221d #M221t} @GROUP;
*   %dp221 = #M221a(in_p) #M221b(in_n) #M221t(tail) @AS $DIFFERENTIAL_PAIR;
*   %cm221 = #M221c(ref) #M221d(out) @AS $CURRENT_MIRROR;
*   %axis221 = (_, _);
*   #M221a(a) #M221b(b) %axis221(axis) @AS $MIRRORED;
*   #M221c(a) #M221d(b) %axis221(axis) @AS $MIRRORED;
*   #M221t {#M221a #M221b} @DISTANCE("bottom-to-top", min=2);
*   {#M221a #M221b} {#M221c #M221d} @DISTANCE("bottom-to-top", min=2);
*   %g222 = {#M222a #M222b #M222c #M222d #M222t} @GROUP;
*   %dp222 = #M222a(in_p) #M222b(in_n) #M222t(tail) @AS $DIFFERENTIAL_PAIR;
*   %cm222 = #M222c(ref) #M222d(out) @AS $CURRENT_MIRROR;
*   %axis222 = (_, _);
*   #M222a(a) #M222b(b) %axis222(axis) @AS $MIRRORED;
*   #M222c(a) #M222d(b) %axis222(axis) @AS $MIRRORED;
*   #M222t {#M222a #M222b} @DISTANCE("bottom-to-top", min=2);
*   {#M222a #M222b} {#M222c #M222d} @DISTANCE("bottom-to-top", min=2);
*   %g223 = {#M223a #M223b #M223c #M223d #M223t} @GROUP;
*   %dp223 = #M223a(in_p) #M223b(in_n) #M223t(tail) @AS $DIFFERENTIAL_PAIR;
*   %cm223 = #M223c(ref) #M223d(out) @AS $CURRENT_MIRROR;
*   %axis223 = (_, _);
*   #M223a(a) #M223b(b) %axis223(axis) @AS $MIRRORED;
*   #M223c(a) #M223d(b) %axis223(axis) @AS $MIRRORED;
*   #M223t {#M223a #M223b} @DISTANCE("bottom-to-top", min=2);
*   {#M223a #M223b} {#M223c #M223d} @DISTANCE("bottom-to-top", min=2);
*   %g224 = {#M224a #M224b #M224c #M224d #M224t} @GROUP;
*   %dp224 = #M224a(in_p) #M224b(in_n) #M224t(tail) @AS $DIFFERENTIAL_PAIR;
*   %cm224 = #M224c(ref) #M224d(out) @AS $CURRENT_MIRROR;
*   %axis224 = (_, _);
*   #M224a(a) #M224b(b) %axis224(axis) @AS $MIRRORED;
*   #M224c(a) #M224d(b) %axis224(axis) @AS $MIRRORED;
*   #M224t {#M224a #M224b} @DISTANCE("bottom-to-top", min=2);
*   {#M224a #M224b} {#M224c #M224d} @DISTANCE("bottom-to-top", min=2);
*   %g225 = {#M225a #M225b #M225c #M225d #M225t} @GROUP;
*   %dp225 = #M225a(in_p) #M225b(in_n) #M225t(tail) @AS $DIFFERENTIAL_PAIR;
*   %cm225 = #M225c(ref) #M225d(out) @AS $CURRENT_MIRROR;
*   %axis225 = (_, _);
*   #M225a(a) #M225b(b) %axis225(axis) @AS $MIRRORED;
*   #M225c(a) #M225d(b) %axis225(axis) @AS $MIRRORED;
*   #M225t {#M225a #M225b} @DISTANCE("bottom-to-top", min=2);
*   {#M225a #M225b} {#M225c #M225d} @DISTANCE("bottom-to-top", min=2);
*   %g226 = {#M226a #M226b #M226c #M226d #M226t} @GROUP;
*   %dp226 = #M226a(in_p) #M226b(in_n) #M226t(tail) @AS $DIFFERENTIAL_PAIR;
*   %cm226 = #M226c(ref) #M226d(out) @AS $CURRENT_MIRROR;
*   %axis226 = (_, _);
*   #M226a(a) #M226b(b) %axis226(axis) @AS $MIRRORED;
*   #M226c(a) #M226d(b) %axis226(axis) @AS $MIRRORED;
*   #M226t {#M226a #M226b} @DISTANCE("bottom-to-top", min=2);
*   {#M226a #M226b} {#M226c #M226d} @DISTANCE("bottom-to-top", min=2);
*   %g227 = {#M227a #M227b #M227c #M227d #M227t} @GROUP;
*   %dp227 = #M227a(in_p) #M227b(in_n) #M227t(tail) @AS $DIFFERENTIAL_PAIR;
*   %cm227 = #M227c(ref) #M227d(out) @AS $CURRENT_MIRROR;
*   %axis227 = (_, _);
*   #M227a(a) #M227b(b) %axis227(axis) @AS $MIRRORED;
*   #M227c(a) #M227d(b) %axis227(axis) @AS $MIRRORED;
*   #M227t {#M227a #M227b} @DISTANCE("bottom-to-top", min=2);
*   {#M227a #M227b} {#M227c #M227d} @DISTANCE("bottom-to-top", min=2);
*   %g228 = {#M228a #M228b #M228c #M228d #M228t} @GROUP;
*   %dp228 = #M228a(in_p) #M228b(in_n) #M228t(tail) @AS $DIFFERENTIAL_PAIR;
*   %cm228 = #M228c(ref) #M228d(out) @AS $CURRENT_MIRROR;
*   %axis228 = (_, _);
*   #M228a(a) #M228b(b) %axis228(axis) @AS $MIRRORED;
*   #M228c(a) #M228d(b) %axis228(axis) @AS $MIRRORED;
*   #M228t {#M228a #M228b} @DISTANCE("bottom-to-top", min=2);
*   {#M228a #M228b} {#M228c #M228d} @DISTANCE("bottom-to-top", min=2);
*   %g229 = {#M229a #M229b #M229c #M229d #M229t} @GROUP;
*   %dp229 = #M229a(in_p) #M229b(in_n) #M229t(tail) @AS $DIFFERENTIAL_PAIR;
*   %cm229 = #M229c(ref) #M229d(out) @AS $CURRENT_MIRROR;
*   %axis229 = (_, _);
*   #M229a(a) #M229b(b) %axis229(axis) @AS $MIRRORED;
*   #M229c(a) #M229d(b) %axis229(axis) @AS $MIRRORED;
*   #M229t {#M229a #M229b} @DISTANCE("bottom-to-top", min=2);
*   {#M229a #M229b} {#M229c #M229d} @DISTANCE("bottom-to-top", min=2);
*   %g230 = {#M230a #M230b #M230c #M230d #M230t} @GROUP;
*   %dp230 = #M230a(in_p) #M230b(in_n) #M230t(tail) @AS $DIFFERENTIAL_PAIR;
*   %cm230 = #M230c(ref) #M230d(out) @AS $CURRENT_MIRROR;
*   %axis230 = (_, _);
*   #M230a(a) #M230b(b) %axis230(axis) @AS $MIRRORED;
*   #M230c(a) #M230d(b) %axis230(axis) @AS $MIRRORED;
*   #M230t {#M230a #M230b} @DISTANCE("bottom-to-top", min=2);
*   {#M230a #M230b} {#M230c #M230d} @DISTANCE("bottom-to-top", min=2);
*   %g231 = {#M231a #M231b #M231c #M231d #M231t} @GROUP;
*   %dp231 = #M231a(in_p) #M231b(in_n) #M231t(tail) @AS $DIFFERENTIAL_PAIR;
*   %cm231 = #M231c(ref) #M231d(out) @AS $CURRENT_MIRROR;
*   %axis231 = (_, _);
*   #M231a(a) #M231b(b) %axis231(axis) @AS $MIRRORED;
*   #M231c(a) #M231d(b) %axis231(axis) @AS $MIRRORED;
*   #M231t {#M231a #M231b} @DISTANCE("bottom-to-top", min=2);
*   {#M231a #M231b} {#M231c #M231d} @DISTANCE("bottom-to-top", min=2);
*   %g232 = {#M232a #M232b #M232c #M232d #M232t} @GROUP;
*   %dp232 = #M232a(in_p) #M232b(in_n) #M232t(tail) @AS $DIFFERENTIAL_PAIR;
*   %cm232 = #M232c(ref) #M232d(out) @AS $CURRENT_MIRROR;
*   %axis232 = (_, _);
*   #M232a(a) #M232b(b) %axis232(axis) @AS $MIRRORED;
*   #M232c(a) #M232d(b) %axis232(axis) @AS $MIRRORED;
*   #M232t {#M232a #M232b} @DISTANCE("bottom-to-top", min=2);
*   {#M232a #M232b} {#M232c #M232d} @DISTANCE("bottom-to-top", min=2);
*   %g233 = {#M233a #M233b #M233c #M233d #M233t} @GROUP;
*   %dp233 = #M233a(in_p) #M233b(in_n) #M233t(tail) @AS $DIFFERENTIAL_PAIR;
*   %cm233 = #M233c(ref) #M233d(out) @AS $CURRENT_MIRROR;
*   %axis233 = (_, _);
*   #M233a(a) #M233b(b) %axis233(axis) @AS $MIRRORED;
*   #M233c(a) #M233d(b) %axis233(axis) @AS $MIRRORED;
*   #M233t {#M233a #M233b} @DISTANCE("bottom-to-top", min=2);
*   {#M233a #M233b} {#M233c #M233d} @DISTANCE("bottom-to-top", min=2);
*   %g234 = {#M234a #M234b #M234c #M234d #M234t} @GROUP;
*   %dp234 = #M234a(in_p) #M234b(in_n) #M234t(tail) @AS $DIFFERENTIAL_PAIR;
*   %cm234 = #M234c(ref) #M234d(out) @AS $CURRENT_MIRROR;
*   %axis234 = (_, _);
*   #M234a(a) #M234b(b) %axis234(axis) @AS $MIRRORED;
*   #M234c(a) #M234d(b) %axis234(axis) @AS $MIRRORED;
*   #M234t {#M234a #M234b} @DISTANCE("bottom-to-top", min=2);
*   {#M234a #M234b} {#M234c #M234d} @DISTANCE("bottom-to-top", min=2);
*   %g235 = {#M235a #M235b #M235c #M235d #M235t} @GROUP;
*   %dp235 = #M235a(in_p) #M235b(in_n) #M235t(tail) @AS $DIFFERENTIAL_PAIR;
*   %cm235 = #M235c(ref) #M235d(out) @AS $CURRENT_MIRROR;
*   %axis235 = (_, _);
*   #M235a(a) #M235b(b) %axis235(axis) @AS $MIRRORED;
*   #M235c(a) #M235d(b) %axis235(axis) @AS $MIRRORED;
*   #M235t {#M235a #M235b} @DISTANCE("bottom-to-top", min=2);
*   {#M235a #M235b} {#M235c #M235d} @DISTANCE("bottom-to-top", min=2);
*   %g236 = {#M236a #M236b #M236c #M236d #M236t} @GROUP;
*   %dp236 = #M236a(in_p) #M236b(in_n) #M236t(tail) @AS $DIFFERENTIAL_PAIR;
*   %cm236 = #M236c(ref) #M236d(out) @AS $CURRENT_MIRROR;
*   %axis236 = (_, _);
*   #M236a(a) #M236b(b) %axis236(axis) @AS $MIRRORED;
*   #M236c(a) #M236d(b) %axis236(axis) @AS $MIRRORED;
*   #M236t {#M236a #M236b} @DISTANCE("bottom-to-top", min=2);
*   {#M236a #M236b} {#M236c #M236d} @DISTANCE("bottom-to-top", min=2);
*   %g237 = {#M237a #M237b #M237c #M237d #M237t} @GROUP;
*   %dp237 = #M237a(in_p) #M237b(in_n) #M237t(tail) @AS $DIFFERENTIAL_PAIR;
*   %cm237 = #M237c(ref) #M237d(out) @AS $CURRENT_MIRROR;
*   %axis237 = (_, _);
*   #M237a(a) #M237b(b) %axis237(axis) @AS $MIRRORED;
*   #M237c(a) #M237d(b) %axis237(axis) @AS $MIRRORED;
*   #M237t {#M237a #M237b} @DISTANCE("bottom-to-top", min=2);
*   {#M237a #M237b} {#M237c #M237d} @DISTANCE("bottom-to-top", min=2);
*   %g238 = {#M238a #M238b #M238c #M238d #M238t} @GROUP;
*   %dp238 = #M238a(in_p) #M238b(in_n) #M238t(tail) @AS $DIFFERENTIAL_PAIR;
*   %cm238 = #M238c(ref) #M238d(out) @AS $CURRENT_MIRROR;
*   %axis238 = (_, _);
*   #M238a(a) #M238b(b) %axis238(axis) @AS $MIRRORED;
*   #M238c(a) #M238d(b) %axis238(axis) @AS $MIRRORED;
*   #M238t {#M238a #M238b} @DISTANCE("bottom-to-top", min=2);
*   {#M238a #M238b} {#M238c #M238d} @DISTANCE("bottom-to-top", min=2);
*   %g239 = {#M239a #M239b #M239c #M239d #M239t} @GROUP;
*   %dp239 = #M239a(in_p) #M239b(in_n) #M239t(tail) @AS $DIFFERENTIAL_PAIR;
*   %cm239 = #M239c(ref) #M239d(out) @AS $CURRENT_MIRROR;
*   %axis239 = (_, _);
*   #M239a(a) #M239b(b) %axis239(axis) @AS $MIRRORED;
*   #M239c(a) #M239d(b) %axis239(axis) @AS $MIRRORED;
*   #M239t {#M239a #M239b} @DISTANCE("bottom-to-top", min=2);
*   {#M239a #M239b} {#M239c #M239d} @DISTANCE("bottom-to-top", min=2);
*   %g240 = {#M240a #M240b #M240c #M240d #M240t} @GROUP;
*   %dp240 = #M240a(in_p) #M240b(in_n) #M240t(tail) @AS $DIFFERENTIAL_PAIR;
*   %cm240 = #M240c(ref) #M240d(out) @AS $CURRENT_MIRROR;
*   %axis240 = (_, _);
*   #M240a(a) #M240b(b) %axis240(axis) @AS $MIRRORED;
*   #M240c(a) #M240d(b) %axis240(axis) @AS $MIRRORED;
*   #M240t {#M240a #M240b} @DISTANCE("bottom-to-top", min=2);
*   {#M240a #M240b} {#M240c #M240d} @DISTANCE("bottom-to-top", min=2);
*   %g241 = {#M241a #M241b #M241c #M241d #M241t} @GROUP;
*   %dp241 = #M241a(in_p) #M241b(in_n) #M241t(tail) @AS $DIFFERENTIAL_PAIR;
*   %cm241 = #M241c(ref) #M241d(out) @AS $CURRENT_MIRROR;
*   %axis241 = (_, _);
*   #M241a(a) #M241b(b) %axis241(axis) @AS $MIRRORED;
*   #M241c(a) #M241d(b) %axis241(axis) @AS $MIRRORED;
*   #M241t {#M241a #M241b} @DISTANCE("bottom-to-top", min=2);
*   {#M241a #M241b} {#M241c #M241d} @DISTANCE("bottom-to-top", min=2);
*   %g242 = {#M242a #M242b #M242c #M242d #M242t} @GROUP;
*   %dp242 = #M242a(in_p) #M242b(in_n) #M242t(tail) @AS $DIFFERENTIAL_PAIR;
*   %cm242 = #M242c(ref) #M242d(out) @AS $CURRENT_MIRROR;
*   %axis242 = (_, _);
*   #M242a(a) #M242b(b) %axis242(axis) @AS $MIRRORED;
*   #M242c(a) #M242d(b) %axis242(axis) @AS $MIRRORED;
*   #M242t {#M242a #M242b} @DISTANCE("bottom-to-top", min=2);
*   {#M242a #M242b} {#M242c #M242d} @DISTANCE("bottom-to-top", min=2);
*   %g243 = {#M243a #M243b #M243c #M243d #M243t} @GROUP;
*   %dp243 = #M243a(in_p) #M243b(in_n) #M243t(tail) @AS $DIFFERENTIAL_PAIR;
*   %cm243 = #M243c(ref) #M243d(out) @AS $CURRENT_MIRROR;
*   %axis243 = (_, _);
*   #M243a(a) #M243b(b) %axis243(axis) @AS $MIRRORED;
*   #M243c(a) #M243d(b) %axis243(axis) @AS $MIRRORED;
*   #M243t {#M243a #M243b} @DISTANCE("bottom-to-top", min=2);
*   {#M243a #M243b} {#M243c #M243d} @DISTANCE("bottom-to-top", min=2);
*   %g244 = {#M244a #M244b #M244c #M244d #M244t} @GROUP;
*   %dp244 = #M244a(in_p) #M244b(in_n) #M244t(tail) @AS $DIFFERENTIAL_PAIR;
*   %cm244 = #M244c(ref) #M244d(out) @AS $CURRENT_MIRROR;
*   %axis244 = (_, _);
*   #M244a(a) #M244b(b) %axis244(axis) @AS $MIRRORED;
*   #M244c(a) #M244d(b) %axis244(axis) @AS $MIRRORED;
*   #M244t {#M244a #M244b} @DISTANCE("bottom-to-top", min=2);
*   {#M244a #M244b} {#M244c #M244d} @DISTANCE("bottom-to-top", min=2);
*   %g245 = {#M245a #M245b #M245c #M245d #M245t} @GROUP;
*   %dp245 = #M245a(in_p) #M245b(in_n) #M245t(tail) @AS $DIFFERENTIAL_PAIR;
*   %cm245 = #M245c(ref) #M245d(out) @AS $CURRENT_MIRROR;
*   %axis245 = (_, _);
*   #M245a(a) #M245b(b) %axis245(axis) @AS $MIRRORED;
*   #M245c(a) #M245d(b) %axis245(axis) @AS $MIRRORED;
*   #M245t {#M245a #M245b} @DISTANCE("bottom-to-top", min=2);
*   {#M245a #M245b} {#M245c #M245d} @DISTANCE("bottom-to-top", min=2);
*   %g246 = {#M246a #M246b #M246c #M246d #M246t} @GROUP;
*   %dp246 = #M246a(in_p) #M246b(in_n) #M246t(tail) @AS $DIFFERENTIAL_PAIR;
*   %cm246 = #M246c(ref) #M246d(out) @AS $CURRENT_MIRROR;
*   %axis246 = (_, _);
*   #M246a(a) #M246b(b) %axis246(axis) @AS $MIRRORED;
*   #M246c(a) #M246d(b) %axis246(axis) @AS $MIRRORED;
*   #M246t {#M246a #M246b} @DISTANCE("bottom-to-top", min=2);
*   {#M246a #M246b} {#M246c #M246d} @DISTANCE("bottom-to-top", min=2);
*   %g247 = {#M247a #M247b #M247c #M247d #M247t} @GROUP;
*   %dp247 = #M247a(in_p) #M247b(in_n) #M247t(tail) @AS $DIFFERENTIAL_PAIR;
*   %cm247 = #M247c(ref) #M247d(out) @AS $CURRENT_MIRROR;
*   %axis247 = (_, _);
*   #M247a(a) #M247b(b) %axis247(axis) @AS $MIRRORED;
*   #M247c(a) #M247d(b) %axis247(axis) @AS $MIRRORED;
*   #M247t {#M247a #M247b} @DISTANCE("bottom-to-top", min=2);
*   {#M247a #M247b} {#M247c #M247d} @DISTANCE("bottom-to-top", min=2);
*   %g248 = {#M248a #M248b #M248c #M248d #M248t} @GROUP;
*   %dp248 = #M248a(in_p) #M248b(in_n) #M248t(tail) @AS $DIFFERENTIAL_PAIR;
*   %cm248 = #M248c(ref) #M248d(out) @AS $CURRENT_MIRROR;
*   %axis248 = (_, _);
*   #M248a(a) #M248b(b) %axis248(axis) @AS $MIRRORED;
*   #M248c(a) #M248d(b) %axis248(axis) @AS $MIRRORED;
*   #M248t {#M248a #M248b} @DISTANCE("bottom-to-top", min=2);
*   {#M248a #M248b} {#M248c #M248d} @DISTANCE("bottom-to-top", min=2);
*   %g249 = {#M249a #M249b #M249c #M249d #M249t} @GROUP;
*   %dp249 = #M249a(in_p) #M249b(in_n) #M249t(tail) @AS $DIFFERENTIAL_PAIR;
*   %cm249 = #M249c(ref) #M249d(out) @AS $CURRENT_MIRROR;
*   %axis249 = (_, _);
*   #M249a(a) #M249b(b) %axis249(axis) @AS $MIRRORED;
*   #M249c(a) #M249d(b) %axis249(axis) @AS $MIRRORED;
*   #M249t {#M249a #M249b} @DISTANCE("bottom-to-top", min=2);
*   {#M249a #M249b} {#M249c #M249d} @DISTANCE("bottom-to-top", min=2);
*   %g250 = {#M250a #M250b #M250c #M250d #M250t} @GROUP;
*   %dp250 = #M250a(in_p) #M250b(in_n) #M250t(tail) @AS $DIFFERENTIAL_PAIR;
*   %cm250 = #M250c(ref) #M250d(out) @AS $CURRENT_MIRROR;
*   %axis250 = (_, _);
*   #M250a(a) #M250b(b) %axis250(axis) @AS $MIRRORED;
*   #M250c(a) #M250d(b) %axis250(axis) @AS $MIRRORED;
*   #M250t {#M250a #M250b} @DISTANCE("bottom-to-top", min=2);
*   {#M250a #M250b} {#M250c #M250d} @DISTANCE("bottom-to-top", min=2);
*   %g251 = {#M251a #M251b #M251c #M251d #M251t} @GROUP;
*   %dp251 = #M251a(in_p) #M251b(in_n) #M251t(tail) @AS $DIFFERENTIAL_PAIR;
*   %cm251 = #M251c(ref) #M251d(out) @AS $CURRENT_MIRROR;
*   %axis251 = (_, _);
*   #M251a(a) #M251b(b) %axis251(axis) @AS $MIRRORED;
*   #M251c(a) #M251d(b) %axis251(axis) @AS $MIRRORED;
*   #M251t {#M251a #M251b} @DISTANCE("bottom-to-top", min=2);
*   {#M251a #M251b} {#M251c #M251d} @DISTANCE("bottom-to-top", min=2);
*   %g252 = {#M252a #M252b #M252c #M252d #M252t} @GROUP;
*   %dp252 = #M252a(in_p) #M252b(in_n) #M252t(tail) @AS $DIFFERENTIAL_PAIR;
*   %cm252 = #M252c(ref) #M252d(out) @AS $CURRENT_MIRROR;
*   %axis252 = (_, _);
*   #M252a(a) #M252b(b) %axis252(axis) @AS $MIRRORED;
*   #M252c(a) #M252d(b) %axis252(axis) @AS $MIRRORED;
*   #M252t {#M252a #M252b} @DISTANCE("bottom-to-top", min=2);
*   {#M252a #M252b} {#M252c #M252d} @DISTANCE("bottom-to-top", min=2);
*   %g253 = {#M253a #M253b #M253c #M253d #M253t} @GROUP;
*   %dp253 = #M253a(in_p) #M253b(in_n) #M253t(tail) @AS $DIFFERENTIAL_PAIR;
*   %cm253 = #M253c(ref) #M253d(out) @AS $CURRENT_MIRROR;
*   %axis253 = (_, _);
*   #M253a(a) #M253b(b) %axis253(axis) @AS $MIRRORED;
*   #M253c(a) #M253d(b) %axis253(axis) @AS $MIRRORED;
*   #M253t {#M253a #M253b} @DISTANCE("bottom-to-top", min=2);
*   {#M253a #M253b} {#M253c #M253d} @DISTANCE("bottom-to-top", min=2);
*   %g254 = {#M254a #M254b #M254c #M254d #M254t} @GROUP;
*   %dp254 = #M254a(in_p) #M254b(in_n) #M254t(tail) @AS $DIFFERENTIAL_PAIR;
*   %cm254 = #M254c(ref) #M254d(out) @AS $CURRENT_MIRROR;
*   %axis254 = (_, _);
*   #M254a(a) #M254b(b) %axis254(axis) @AS $MIRRORED;
*   #M254c(a) #M254d(b) %axis254(axis) @AS $MIRRORED;
*   #M254t {#M254a #M254b} @DISTANCE("bottom-to-top", min=2);
*   {#M254a #M254b} {#M254c #M254d} @DISTANCE("bottom-to-top", min=2);
*   %g255 = {#M255a #M255b #M255c #M255d #M255t} @GROUP;
*   %dp255 = #M255a(in_p) #M255b(in_n) #M255t(tail) @AS $DIFFERENTIAL_PAIR;
*   %cm255 = #M255c(ref) #M255d(out) @AS $CURRENT_MIRROR;
*   %axis255 = (_, _);
*   #M255a(a) #M255b(b) %axis255(axis) @AS $MIRRORED;
*   #M255c(a) #M255d(b) %axis255(axis) @AS $MIRRORED;
*   #M255t {#M255a #M255b} @DISTANCE("bottom-to-top", min=2);
*   {#M255a #M255b} {#M255c #M255d} @DISTANCE("bottom-to-top", min=2);
*   {%g0 %g1 %g2 %g3 %g4 %g5 %g6 %g7 %g8 %g9 %g10 %g11 %g12 %g13 %g14 %g15 %g16 %g17 %g18 %g19 %g20 %g21 %g22 %g23 %g24 %g25 %g26 %g27 %g28 %g29 %g30 %g31 %g32 %g33 %g34 %g35 %g36 %g37 %g38 %g39 %g40 %g41 %g42 %g43 %g44 %g45 %g46 %g47 %g48 %g49 %g50 %g51 %g52 %g53 %g54 %g55 %g56 %g57 %g58 %g59 %g60 %g61 %g62 %g63 %g64 %g65 %g66 %g67 %g68 %g69 %g70 %g71 %g72 %g73 %g74 %g75 %g76 %g77 %g78 %g79 %g80 %g81 %g82 %g83 %g84 %g85 %g86 %g87 %g88 %g89 %g90 %g91 %g92 %g93 %g94 %g95 %g96 %g97 %g98 %g99 %g100 %g101 %g102 %g103 %g104 %g105 %g106 %g107 %g108 %g109 %g110 %g111 %g112 %g113 %g114 %g115 %g116 %g117 %g118 %g119 %g120 %g121 %g122 %g123 %g124 %g125 %g126 %g127 %g128 %g129 %g130 %g131 %g132 %g133 %g134 %g135 %g136 %g137 %g138 %g139 %g140 %g141 %g142 %g143 %g144 %g145 %g146 %g147 %g148 %g149 %g150 %g151 %g152 %g153 %g154 %g155 %g156 %g157 %g158 %g159 %g160 %g161 %g162 %g163 %g164 %g165 %g166 %g167 %g168 %g169 %g170 %g171 %g172 %g173 %g174 %g175 %g176 %g177 %g178 %g179 %g180 %g181 %g182 %g183 %g184 %g185 %g186 %g187 %g188 %g189 %g190 %g191 %g192 %g193 %g194 %g195 %g196 %g197 %g198 %g199 %g200 %g201 %g202 %g203 %g204 %g205 %g206 %g207 %g208 %g209 %g210 %g211 %g212 %g213 %g214 %g215 %g216 %g217 %g218 %g219 %g220 %g221 %g222 %g223 %g224 %g225 %g226 %g227 %g228 %g229 %g230 %g231 %g232 %g233 %g234 %g235 %g236 %g237 %g238 %g239 %g240 %g241 %g242 %g243 %g244 %g245 %g246 %g247 %g248 %g249 %g250 %g251 %g252 %g253 %g254 %g255} @AS $FLOW;
*   $WIRE_NET_SET @ROUTE
* }
.end
