* Synthetic disjunctions; n=16; generated by prepare_inputs.py
* @RNL(type="header") { @VERSION("0.3") }
R0 q0 q1 1k
R1 q1 q2 1k
R2 q2 q3 1k
R3 q3 q4 1k
R4 q4 q5 1k
R5 q5 q6 1k
R6 q6 q7 1k
R7 q7 q8 1k
R8 q8 q9 1k
R9 q9 q10 1k
R10 q10 q11 1k
R11 q11 q12 1k
R12 q12 q13 1k
R13 q13 q14 1k
R14 q14 q15 1k
R15 q15 q16 1k
R16 q16 q17 1k
R17 q17 q18 1k
R18 q18 q19 1k
R19 q19 q20 1k
R20 q20 q21 1k
R21 q21 q22 1k
R22 q22 q23 1k
R23 q23 q24 1k
R24 q24 q25 1k
R25 q25 q26 1k
R26 q26 q27 1k
R27 q27 q28 1k
R28 q28 q29 1k
R29 q29 q30 1k
R30 q30 q31 1k
R31 q31 q32 1k
* @RNL {
*   #R0 @PLACE(0, 0);
*   #R1 @PLACE(y=0);
*   #R0 #R1 @DISTANCE("x", min=8, max=12);
*   #R2 @PLACE(20, 0);
*   #R3 @PLACE(y=0);
*   #R2 #R3 @DISTANCE("x", min=8, max=12);
*   #R4 @PLACE(40, 0);
*   #R5 @PLACE(y=0);
*   #R4 #R5 @DISTANCE("x", min=8, max=12);
*   #R6 @PLACE(60, 0);
*   #R7 @PLACE(y=0);
*   #R6 #R7 @DISTANCE("x", min=8, max=12);
*   #R8 @PLACE(80, 0);
*   #R9 @PLACE(y=0);
*   #R8 #R9 @DISTANCE("x", min=8, max=12);
*   #R10 @PLACE(100, 0);
*   #R11 @PLACE(y=0);
*   #R10 #R11 @DISTANCE("x", min=8, max=12);
*   #R12 @PLACE(120, 0);
*   #R13 @PLACE(y=0);
*   #R12 #R13 @DISTANCE("x", min=8, max=12);
*   #R14 @PLACE(140, 0);
*   #R15 @PLACE(y=0);
*   #R14 #R15 @DISTANCE("x", min=8, max=12);
*   #R16 @PLACE(160, 0);
*   #R17 @PLACE(y=0);
*   #R16 #R17 @DISTANCE("x", min=8, max=12);
*   #R18 @PLACE(180, 0);
*   #R19 @PLACE(y=0);
*   #R18 #R19 @DISTANCE("x", min=8, max=12);
*   #R20 @PLACE(200, 0);
*   #R21 @PLACE(y=0);
*   #R20 #R21 @DISTANCE("x", min=8, max=12);
*   #R22 @PLACE(220, 0);
*   #R23 @PLACE(y=0);
*   #R22 #R23 @DISTANCE("x", min=8, max=12);
*   #R24 @PLACE(240, 0);
*   #R25 @PLACE(y=0);
*   #R24 #R25 @DISTANCE("x", min=8, max=12);
*   #R26 @PLACE(260, 0);
*   #R27 @PLACE(y=0);
*   #R26 #R27 @DISTANCE("x", min=8, max=12);
*   #R28 @PLACE(280, 0);
*   #R29 @PLACE(y=0);
*   #R28 #R29 @DISTANCE("x", min=8, max=12);
*   #R30 @PLACE(300, 0);
*   #R31 @PLACE(y=0);
*   #R30 #R31 @DISTANCE("x", min=8, max=12);
*   $WIRE_NET_SET @ROUTE
* }
.end
