* Synthetic disjunctions; n=32; generated by prepare_inputs.py
* @RNL(type="header") { @VERSION("0.3") }
R0 q0 q1 1k
R1 q1 q2 1k
R2 q2 q3 1k
R3 q3 q4 1k
R4 q4 q5 1k
R5 q5 q6 1k
R6 q6 q7 1k
R7 q7 q8 1k
R8 q8 q9 1k
R9 q9 q10 1k
R10 q10 q11 1k
R11 q11 q12 1k
R12 q12 q13 1k
R13 q13 q14 1k
R14 q14 q15 1k
R15 q15 q16 1k
R16 q16 q17 1k
R17 q17 q18 1k
R18 q18 q19 1k
R19 q19 q20 1k
R20 q20 q21 1k
R21 q21 q22 1k
R22 q22 q23 1k
R23 q23 q24 1k
R24 q24 q25 1k
R25 q25 q26 1k
R26 q26 q27 1k
R27 q27 q28 1k
R28 q28 q29 1k
R29 q29 q30 1k
R30 q30 q31 1k
R31 q31 q32 1k
R32 q32 q33 1k
R33 q33 q34 1k
R34 q34 q35 1k
R35 q35 q36 1k
R36 q36 q37 1k
R37 q37 q38 1k
R38 q38 q39 1k
R39 q39 q40 1k
R40 q40 q41 1k
R41 q41 q42 1k
R42 q42 q43 1k
R43 q43 q44 1k
R44 q44 q45 1k
R45 q45 q46 1k
R46 q46 q47 1k
R47 q47 q48 1k
R48 q48 q49 1k
R49 q49 q50 1k
R50 q50 q51 1k
R51 q51 q52 1k
R52 q52 q53 1k
R53 q53 q54 1k
R54 q54 q55 1k
R55 q55 q56 1k
R56 q56 q57 1k
R57 q57 q58 1k
R58 q58 q59 1k
R59 q59 q60 1k
R60 q60 q61 1k
R61 q61 q62 1k
R62 q62 q63 1k
R63 q63 q64 1k
* @RNL {
*   #R0 @PLACE(0, 0);
*   #R1 @PLACE(y=0);
*   #R0 #R1 @DISTANCE("x", min=8, max=12);
*   #R2 @PLACE(20, 0);
*   #R3 @PLACE(y=0);
*   #R2 #R3 @DISTANCE("x", min=8, max=12);
*   #R4 @PLACE(40, 0);
*   #R5 @PLACE(y=0);
*   #R4 #R5 @DISTANCE("x", min=8, max=12);
*   #R6 @PLACE(60, 0);
*   #R7 @PLACE(y=0);
*   #R6 #R7 @DISTANCE("x", min=8, max=12);
*   #R8 @PLACE(80, 0);
*   #R9 @PLACE(y=0);
*   #R8 #R9 @DISTANCE("x", min=8, max=12);
*   #R10 @PLACE(100, 0);
*   #R11 @PLACE(y=0);
*   #R10 #R11 @DISTANCE("x", min=8, max=12);
*   #R12 @PLACE(120, 0);
*   #R13 @PLACE(y=0);
*   #R12 #R13 @DISTANCE("x", min=8, max=12);
*   #R14 @PLACE(140, 0);
*   #R15 @PLACE(y=0);
*   #R14 #R15 @DISTANCE("x", min=8, max=12);
*   #R16 @PLACE(160, 0);
*   #R17 @PLACE(y=0);
*   #R16 #R17 @DISTANCE("x", min=8, max=12);
*   #R18 @PLACE(180, 0);
*   #R19 @PLACE(y=0);
*   #R18 #R19 @DISTANCE("x", min=8, max=12);
*   #R20 @PLACE(200, 0);
*   #R21 @PLACE(y=0);
*   #R20 #R21 @DISTANCE("x", min=8, max=12);
*   #R22 @PLACE(220, 0);
*   #R23 @PLACE(y=0);
*   #R22 #R23 @DISTANCE("x", min=8, max=12);
*   #R24 @PLACE(240, 0);
*   #R25 @PLACE(y=0);
*   #R24 #R25 @DISTANCE("x", min=8, max=12);
*   #R26 @PLACE(260, 0);
*   #R27 @PLACE(y=0);
*   #R26 #R27 @DISTANCE("x", min=8, max=12);
*   #R28 @PLACE(280, 0);
*   #R29 @PLACE(y=0);
*   #R28 #R29 @DISTANCE("x", min=8, max=12);
*   #R30 @PLACE(300, 0);
*   #R31 @PLACE(y=0);
*   #R30 #R31 @DISTANCE("x", min=8, max=12);
*   #R32 @PLACE(320, 0);
*   #R33 @PLACE(y=0);
*   #R32 #R33 @DISTANCE("x", min=8, max=12);
*   #R34 @PLACE(340, 0);
*   #R35 @PLACE(y=0);
*   #R34 #R35 @DISTANCE("x", min=8, max=12);
*   #R36 @PLACE(360, 0);
*   #R37 @PLACE(y=0);
*   #R36 #R37 @DISTANCE("x", min=8, max=12);
*   #R38 @PLACE(380, 0);
*   #R39 @PLACE(y=0);
*   #R38 #R39 @DISTANCE("x", min=8, max=12);
*   #R40 @PLACE(400, 0);
*   #R41 @PLACE(y=0);
*   #R40 #R41 @DISTANCE("x", min=8, max=12);
*   #R42 @PLACE(420, 0);
*   #R43 @PLACE(y=0);
*   #R42 #R43 @DISTANCE("x", min=8, max=12);
*   #R44 @PLACE(440, 0);
*   #R45 @PLACE(y=0);
*   #R44 #R45 @DISTANCE("x", min=8, max=12);
*   #R46 @PLACE(460, 0);
*   #R47 @PLACE(y=0);
*   #R46 #R47 @DISTANCE("x", min=8, max=12);
*   #R48 @PLACE(480, 0);
*   #R49 @PLACE(y=0);
*   #R48 #R49 @DISTANCE("x", min=8, max=12);
*   #R50 @PLACE(500, 0);
*   #R51 @PLACE(y=0);
*   #R50 #R51 @DISTANCE("x", min=8, max=12);
*   #R52 @PLACE(520, 0);
*   #R53 @PLACE(y=0);
*   #R52 #R53 @DISTANCE("x", min=8, max=12);
*   #R54 @PLACE(540, 0);
*   #R55 @PLACE(y=0);
*   #R54 #R55 @DISTANCE("x", min=8, max=12);
*   #R56 @PLACE(560, 0);
*   #R57 @PLACE(y=0);
*   #R56 #R57 @DISTANCE("x", min=8, max=12);
*   #R58 @PLACE(580, 0);
*   #R59 @PLACE(y=0);
*   #R58 #R59 @DISTANCE("x", min=8, max=12);
*   #R60 @PLACE(600, 0);
*   #R61 @PLACE(y=0);
*   #R60 #R61 @DISTANCE("x", min=8, max=12);
*   #R62 @PLACE(620, 0);
*   #R63 @PLACE(y=0);
*   #R62 #R63 @DISTANCE("x", min=8, max=12);
*   $WIRE_NET_SET @ROUTE
* }
.end
