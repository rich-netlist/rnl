* Synthetic disjunctions; n=8; generated by prepare_inputs.py
* @RNL(type="header") { @VERSION("0.3") }
R0 q0 q1 1k
R1 q1 q2 1k
R2 q2 q3 1k
R3 q3 q4 1k
R4 q4 q5 1k
R5 q5 q6 1k
R6 q6 q7 1k
R7 q7 q8 1k
R8 q8 q9 1k
R9 q9 q10 1k
R10 q10 q11 1k
R11 q11 q12 1k
R12 q12 q13 1k
R13 q13 q14 1k
R14 q14 q15 1k
R15 q15 q16 1k
* @RNL {
*   #R0 @PLACE(0, 0);
*   #R1 @PLACE(y=0);
*   #R0 #R1 @DISTANCE("x", min=8, max=12);
*   #R2 @PLACE(20, 0);
*   #R3 @PLACE(y=0);
*   #R2 #R3 @DISTANCE("x", min=8, max=12);
*   #R4 @PLACE(40, 0);
*   #R5 @PLACE(y=0);
*   #R4 #R5 @DISTANCE("x", min=8, max=12);
*   #R6 @PLACE(60, 0);
*   #R7 @PLACE(y=0);
*   #R6 #R7 @DISTANCE("x", min=8, max=12);
*   #R8 @PLACE(80, 0);
*   #R9 @PLACE(y=0);
*   #R8 #R9 @DISTANCE("x", min=8, max=12);
*   #R10 @PLACE(100, 0);
*   #R11 @PLACE(y=0);
*   #R10 #R11 @DISTANCE("x", min=8, max=12);
*   #R12 @PLACE(120, 0);
*   #R13 @PLACE(y=0);
*   #R12 #R13 @DISTANCE("x", min=8, max=12);
*   #R14 @PLACE(140, 0);
*   #R15 @PLACE(y=0);
*   #R14 #R15 @DISTANCE("x", min=8, max=12);
*   $WIRE_NET_SET @ROUTE
* }
.end
