* Synthetic disjunctions; n=2; generated by prepare_inputs.py
* @RNL(type="header") { @VERSION("0.3") }
R0 q0 q1 1k
R1 q1 q2 1k
R2 q2 q3 1k
R3 q3 q4 1k
* @RNL {
*   #R0 @PLACE(0, 0);
*   #R1 @PLACE(y=0);
*   #R0 #R1 @DISTANCE("x", min=8, max=12);
*   #R2 @PLACE(20, 0);
*   #R3 @PLACE(y=0);
*   #R2 #R3 @DISTANCE("x", min=8, max=12);
*   $WIRE_NET_SET @ROUTE
* }
.end
