* Synthetic disjunctions; n=128; generated by prepare_inputs.py
* @RNL(type="header") { @VERSION("0.3") }
R0 q0 q1 1k
R1 q1 q2 1k
R2 q2 q3 1k
R3 q3 q4 1k
R4 q4 q5 1k
R5 q5 q6 1k
R6 q6 q7 1k
R7 q7 q8 1k
R8 q8 q9 1k
R9 q9 q10 1k
R10 q10 q11 1k
R11 q11 q12 1k
R12 q12 q13 1k
R13 q13 q14 1k
R14 q14 q15 1k
R15 q15 q16 1k
R16 q16 q17 1k
R17 q17 q18 1k
R18 q18 q19 1k
R19 q19 q20 1k
R20 q20 q21 1k
R21 q21 q22 1k
R22 q22 q23 1k
R23 q23 q24 1k
R24 q24 q25 1k
R25 q25 q26 1k
R26 q26 q27 1k
R27 q27 q28 1k
R28 q28 q29 1k
R29 q29 q30 1k
R30 q30 q31 1k
R31 q31 q32 1k
R32 q32 q33 1k
R33 q33 q34 1k
R34 q34 q35 1k
R35 q35 q36 1k
R36 q36 q37 1k
R37 q37 q38 1k
R38 q38 q39 1k
R39 q39 q40 1k
R40 q40 q41 1k
R41 q41 q42 1k
R42 q42 q43 1k
R43 q43 q44 1k
R44 q44 q45 1k
R45 q45 q46 1k
R46 q46 q47 1k
R47 q47 q48 1k
R48 q48 q49 1k
R49 q49 q50 1k
R50 q50 q51 1k
R51 q51 q52 1k
R52 q52 q53 1k
R53 q53 q54 1k
R54 q54 q55 1k
R55 q55 q56 1k
R56 q56 q57 1k
R57 q57 q58 1k
R58 q58 q59 1k
R59 q59 q60 1k
R60 q60 q61 1k
R61 q61 q62 1k
R62 q62 q63 1k
R63 q63 q64 1k
R64 q64 q65 1k
R65 q65 q66 1k
R66 q66 q67 1k
R67 q67 q68 1k
R68 q68 q69 1k
R69 q69 q70 1k
R70 q70 q71 1k
R71 q71 q72 1k
R72 q72 q73 1k
R73 q73 q74 1k
R74 q74 q75 1k
R75 q75 q76 1k
R76 q76 q77 1k
R77 q77 q78 1k
R78 q78 q79 1k
R79 q79 q80 1k
R80 q80 q81 1k
R81 q81 q82 1k
R82 q82 q83 1k
R83 q83 q84 1k
R84 q84 q85 1k
R85 q85 q86 1k
R86 q86 q87 1k
R87 q87 q88 1k
R88 q88 q89 1k
R89 q89 q90 1k
R90 q90 q91 1k
R91 q91 q92 1k
R92 q92 q93 1k
R93 q93 q94 1k
R94 q94 q95 1k
R95 q95 q96 1k
R96 q96 q97 1k
R97 q97 q98 1k
R98 q98 q99 1k
R99 q99 q100 1k
R100 q100 q101 1k
R101 q101 q102 1k
R102 q102 q103 1k
R103 q103 q104 1k
R104 q104 q105 1k
R105 q105 q106 1k
R106 q106 q107 1k
R107 q107 q108 1k
R108 q108 q109 1k
R109 q109 q110 1k
R110 q110 q111 1k
R111 q111 q112 1k
R112 q112 q113 1k
R113 q113 q114 1k
R114 q114 q115 1k
R115 q115 q116 1k
R116 q116 q117 1k
R117 q117 q118 1k
R118 q118 q119 1k
R119 q119 q120 1k
R120 q120 q121 1k
R121 q121 q122 1k
R122 q122 q123 1k
R123 q123 q124 1k
R124 q124 q125 1k
R125 q125 q126 1k
R126 q126 q127 1k
R127 q127 q128 1k
R128 q128 q129 1k
R129 q129 q130 1k
R130 q130 q131 1k
R131 q131 q132 1k
R132 q132 q133 1k
R133 q133 q134 1k
R134 q134 q135 1k
R135 q135 q136 1k
R136 q136 q137 1k
R137 q137 q138 1k
R138 q138 q139 1k
R139 q139 q140 1k
R140 q140 q141 1k
R141 q141 q142 1k
R142 q142 q143 1k
R143 q143 q144 1k
R144 q144 q145 1k
R145 q145 q146 1k
R146 q146 q147 1k
R147 q147 q148 1k
R148 q148 q149 1k
R149 q149 q150 1k
R150 q150 q151 1k
R151 q151 q152 1k
R152 q152 q153 1k
R153 q153 q154 1k
R154 q154 q155 1k
R155 q155 q156 1k
R156 q156 q157 1k
R157 q157 q158 1k
R158 q158 q159 1k
R159 q159 q160 1k
R160 q160 q161 1k
R161 q161 q162 1k
R162 q162 q163 1k
R163 q163 q164 1k
R164 q164 q165 1k
R165 q165 q166 1k
R166 q166 q167 1k
R167 q167 q168 1k
R168 q168 q169 1k
R169 q169 q170 1k
R170 q170 q171 1k
R171 q171 q172 1k
R172 q172 q173 1k
R173 q173 q174 1k
R174 q174 q175 1k
R175 q175 q176 1k
R176 q176 q177 1k
R177 q177 q178 1k
R178 q178 q179 1k
R179 q179 q180 1k
R180 q180 q181 1k
R181 q181 q182 1k
R182 q182 q183 1k
R183 q183 q184 1k
R184 q184 q185 1k
R185 q185 q186 1k
R186 q186 q187 1k
R187 q187 q188 1k
R188 q188 q189 1k
R189 q189 q190 1k
R190 q190 q191 1k
R191 q191 q192 1k
R192 q192 q193 1k
R193 q193 q194 1k
R194 q194 q195 1k
R195 q195 q196 1k
R196 q196 q197 1k
R197 q197 q198 1k
R198 q198 q199 1k
R199 q199 q200 1k
R200 q200 q201 1k
R201 q201 q202 1k
R202 q202 q203 1k
R203 q203 q204 1k
R204 q204 q205 1k
R205 q205 q206 1k
R206 q206 q207 1k
R207 q207 q208 1k
R208 q208 q209 1k
R209 q209 q210 1k
R210 q210 q211 1k
R211 q211 q212 1k
R212 q212 q213 1k
R213 q213 q214 1k
R214 q214 q215 1k
R215 q215 q216 1k
R216 q216 q217 1k
R217 q217 q218 1k
R218 q218 q219 1k
R219 q219 q220 1k
R220 q220 q221 1k
R221 q221 q222 1k
R222 q222 q223 1k
R223 q223 q224 1k
R224 q224 q225 1k
R225 q225 q226 1k
R226 q226 q227 1k
R227 q227 q228 1k
R228 q228 q229 1k
R229 q229 q230 1k
R230 q230 q231 1k
R231 q231 q232 1k
R232 q232 q233 1k
R233 q233 q234 1k
R234 q234 q235 1k
R235 q235 q236 1k
R236 q236 q237 1k
R237 q237 q238 1k
R238 q238 q239 1k
R239 q239 q240 1k
R240 q240 q241 1k
R241 q241 q242 1k
R242 q242 q243 1k
R243 q243 q244 1k
R244 q244 q245 1k
R245 q245 q246 1k
R246 q246 q247 1k
R247 q247 q248 1k
R248 q248 q249 1k
R249 q249 q250 1k
R250 q250 q251 1k
R251 q251 q252 1k
R252 q252 q253 1k
R253 q253 q254 1k
R254 q254 q255 1k
R255 q255 q256 1k
* @RNL {
*   #R0 @PLACE(0, 0);
*   #R1 @PLACE(y=0);
*   #R0 #R1 @DISTANCE("x", min=8, max=12);
*   #R2 @PLACE(20, 0);
*   #R3 @PLACE(y=0);
*   #R2 #R3 @DISTANCE("x", min=8, max=12);
*   #R4 @PLACE(40, 0);
*   #R5 @PLACE(y=0);
*   #R4 #R5 @DISTANCE("x", min=8, max=12);
*   #R6 @PLACE(60, 0);
*   #R7 @PLACE(y=0);
*   #R6 #R7 @DISTANCE("x", min=8, max=12);
*   #R8 @PLACE(80, 0);
*   #R9 @PLACE(y=0);
*   #R8 #R9 @DISTANCE("x", min=8, max=12);
*   #R10 @PLACE(100, 0);
*   #R11 @PLACE(y=0);
*   #R10 #R11 @DISTANCE("x", min=8, max=12);
*   #R12 @PLACE(120, 0);
*   #R13 @PLACE(y=0);
*   #R12 #R13 @DISTANCE("x", min=8, max=12);
*   #R14 @PLACE(140, 0);
*   #R15 @PLACE(y=0);
*   #R14 #R15 @DISTANCE("x", min=8, max=12);
*   #R16 @PLACE(160, 0);
*   #R17 @PLACE(y=0);
*   #R16 #R17 @DISTANCE("x", min=8, max=12);
*   #R18 @PLACE(180, 0);
*   #R19 @PLACE(y=0);
*   #R18 #R19 @DISTANCE("x", min=8, max=12);
*   #R20 @PLACE(200, 0);
*   #R21 @PLACE(y=0);
*   #R20 #R21 @DISTANCE("x", min=8, max=12);
*   #R22 @PLACE(220, 0);
*   #R23 @PLACE(y=0);
*   #R22 #R23 @DISTANCE("x", min=8, max=12);
*   #R24 @PLACE(240, 0);
*   #R25 @PLACE(y=0);
*   #R24 #R25 @DISTANCE("x", min=8, max=12);
*   #R26 @PLACE(260, 0);
*   #R27 @PLACE(y=0);
*   #R26 #R27 @DISTANCE("x", min=8, max=12);
*   #R28 @PLACE(280, 0);
*   #R29 @PLACE(y=0);
*   #R28 #R29 @DISTANCE("x", min=8, max=12);
*   #R30 @PLACE(300, 0);
*   #R31 @PLACE(y=0);
*   #R30 #R31 @DISTANCE("x", min=8, max=12);
*   #R32 @PLACE(320, 0);
*   #R33 @PLACE(y=0);
*   #R32 #R33 @DISTANCE("x", min=8, max=12);
*   #R34 @PLACE(340, 0);
*   #R35 @PLACE(y=0);
*   #R34 #R35 @DISTANCE("x", min=8, max=12);
*   #R36 @PLACE(360, 0);
*   #R37 @PLACE(y=0);
*   #R36 #R37 @DISTANCE("x", min=8, max=12);
*   #R38 @PLACE(380, 0);
*   #R39 @PLACE(y=0);
*   #R38 #R39 @DISTANCE("x", min=8, max=12);
*   #R40 @PLACE(400, 0);
*   #R41 @PLACE(y=0);
*   #R40 #R41 @DISTANCE("x", min=8, max=12);
*   #R42 @PLACE(420, 0);
*   #R43 @PLACE(y=0);
*   #R42 #R43 @DISTANCE("x", min=8, max=12);
*   #R44 @PLACE(440, 0);
*   #R45 @PLACE(y=0);
*   #R44 #R45 @DISTANCE("x", min=8, max=12);
*   #R46 @PLACE(460, 0);
*   #R47 @PLACE(y=0);
*   #R46 #R47 @DISTANCE("x", min=8, max=12);
*   #R48 @PLACE(480, 0);
*   #R49 @PLACE(y=0);
*   #R48 #R49 @DISTANCE("x", min=8, max=12);
*   #R50 @PLACE(500, 0);
*   #R51 @PLACE(y=0);
*   #R50 #R51 @DISTANCE("x", min=8, max=12);
*   #R52 @PLACE(520, 0);
*   #R53 @PLACE(y=0);
*   #R52 #R53 @DISTANCE("x", min=8, max=12);
*   #R54 @PLACE(540, 0);
*   #R55 @PLACE(y=0);
*   #R54 #R55 @DISTANCE("x", min=8, max=12);
*   #R56 @PLACE(560, 0);
*   #R57 @PLACE(y=0);
*   #R56 #R57 @DISTANCE("x", min=8, max=12);
*   #R58 @PLACE(580, 0);
*   #R59 @PLACE(y=0);
*   #R58 #R59 @DISTANCE("x", min=8, max=12);
*   #R60 @PLACE(600, 0);
*   #R61 @PLACE(y=0);
*   #R60 #R61 @DISTANCE("x", min=8, max=12);
*   #R62 @PLACE(620, 0);
*   #R63 @PLACE(y=0);
*   #R62 #R63 @DISTANCE("x", min=8, max=12);
*   #R64 @PLACE(640, 0);
*   #R65 @PLACE(y=0);
*   #R64 #R65 @DISTANCE("x", min=8, max=12);
*   #R66 @PLACE(660, 0);
*   #R67 @PLACE(y=0);
*   #R66 #R67 @DISTANCE("x", min=8, max=12);
*   #R68 @PLACE(680, 0);
*   #R69 @PLACE(y=0);
*   #R68 #R69 @DISTANCE("x", min=8, max=12);
*   #R70 @PLACE(700, 0);
*   #R71 @PLACE(y=0);
*   #R70 #R71 @DISTANCE("x", min=8, max=12);
*   #R72 @PLACE(720, 0);
*   #R73 @PLACE(y=0);
*   #R72 #R73 @DISTANCE("x", min=8, max=12);
*   #R74 @PLACE(740, 0);
*   #R75 @PLACE(y=0);
*   #R74 #R75 @DISTANCE("x", min=8, max=12);
*   #R76 @PLACE(760, 0);
*   #R77 @PLACE(y=0);
*   #R76 #R77 @DISTANCE("x", min=8, max=12);
*   #R78 @PLACE(780, 0);
*   #R79 @PLACE(y=0);
*   #R78 #R79 @DISTANCE("x", min=8, max=12);
*   #R80 @PLACE(800, 0);
*   #R81 @PLACE(y=0);
*   #R80 #R81 @DISTANCE("x", min=8, max=12);
*   #R82 @PLACE(820, 0);
*   #R83 @PLACE(y=0);
*   #R82 #R83 @DISTANCE("x", min=8, max=12);
*   #R84 @PLACE(840, 0);
*   #R85 @PLACE(y=0);
*   #R84 #R85 @DISTANCE("x", min=8, max=12);
*   #R86 @PLACE(860, 0);
*   #R87 @PLACE(y=0);
*   #R86 #R87 @DISTANCE("x", min=8, max=12);
*   #R88 @PLACE(880, 0);
*   #R89 @PLACE(y=0);
*   #R88 #R89 @DISTANCE("x", min=8, max=12);
*   #R90 @PLACE(900, 0);
*   #R91 @PLACE(y=0);
*   #R90 #R91 @DISTANCE("x", min=8, max=12);
*   #R92 @PLACE(920, 0);
*   #R93 @PLACE(y=0);
*   #R92 #R93 @DISTANCE("x", min=8, max=12);
*   #R94 @PLACE(940, 0);
*   #R95 @PLACE(y=0);
*   #R94 #R95 @DISTANCE("x", min=8, max=12);
*   #R96 @PLACE(960, 0);
*   #R97 @PLACE(y=0);
*   #R96 #R97 @DISTANCE("x", min=8, max=12);
*   #R98 @PLACE(980, 0);
*   #R99 @PLACE(y=0);
*   #R98 #R99 @DISTANCE("x", min=8, max=12);
*   #R100 @PLACE(1000, 0);
*   #R101 @PLACE(y=0);
*   #R100 #R101 @DISTANCE("x", min=8, max=12);
*   #R102 @PLACE(1020, 0);
*   #R103 @PLACE(y=0);
*   #R102 #R103 @DISTANCE("x", min=8, max=12);
*   #R104 @PLACE(1040, 0);
*   #R105 @PLACE(y=0);
*   #R104 #R105 @DISTANCE("x", min=8, max=12);
*   #R106 @PLACE(1060, 0);
*   #R107 @PLACE(y=0);
*   #R106 #R107 @DISTANCE("x", min=8, max=12);
*   #R108 @PLACE(1080, 0);
*   #R109 @PLACE(y=0);
*   #R108 #R109 @DISTANCE("x", min=8, max=12);
*   #R110 @PLACE(1100, 0);
*   #R111 @PLACE(y=0);
*   #R110 #R111 @DISTANCE("x", min=8, max=12);
*   #R112 @PLACE(1120, 0);
*   #R113 @PLACE(y=0);
*   #R112 #R113 @DISTANCE("x", min=8, max=12);
*   #R114 @PLACE(1140, 0);
*   #R115 @PLACE(y=0);
*   #R114 #R115 @DISTANCE("x", min=8, max=12);
*   #R116 @PLACE(1160, 0);
*   #R117 @PLACE(y=0);
*   #R116 #R117 @DISTANCE("x", min=8, max=12);
*   #R118 @PLACE(1180, 0);
*   #R119 @PLACE(y=0);
*   #R118 #R119 @DISTANCE("x", min=8, max=12);
*   #R120 @PLACE(1200, 0);
*   #R121 @PLACE(y=0);
*   #R120 #R121 @DISTANCE("x", min=8, max=12);
*   #R122 @PLACE(1220, 0);
*   #R123 @PLACE(y=0);
*   #R122 #R123 @DISTANCE("x", min=8, max=12);
*   #R124 @PLACE(1240, 0);
*   #R125 @PLACE(y=0);
*   #R124 #R125 @DISTANCE("x", min=8, max=12);
*   #R126 @PLACE(1260, 0);
*   #R127 @PLACE(y=0);
*   #R126 #R127 @DISTANCE("x", min=8, max=12);
*   #R128 @PLACE(1280, 0);
*   #R129 @PLACE(y=0);
*   #R128 #R129 @DISTANCE("x", min=8, max=12);
*   #R130 @PLACE(1300, 0);
*   #R131 @PLACE(y=0);
*   #R130 #R131 @DISTANCE("x", min=8, max=12);
*   #R132 @PLACE(1320, 0);
*   #R133 @PLACE(y=0);
*   #R132 #R133 @DISTANCE("x", min=8, max=12);
*   #R134 @PLACE(1340, 0);
*   #R135 @PLACE(y=0);
*   #R134 #R135 @DISTANCE("x", min=8, max=12);
*   #R136 @PLACE(1360, 0);
*   #R137 @PLACE(y=0);
*   #R136 #R137 @DISTANCE("x", min=8, max=12);
*   #R138 @PLACE(1380, 0);
*   #R139 @PLACE(y=0);
*   #R138 #R139 @DISTANCE("x", min=8, max=12);
*   #R140 @PLACE(1400, 0);
*   #R141 @PLACE(y=0);
*   #R140 #R141 @DISTANCE("x", min=8, max=12);
*   #R142 @PLACE(1420, 0);
*   #R143 @PLACE(y=0);
*   #R142 #R143 @DISTANCE("x", min=8, max=12);
*   #R144 @PLACE(1440, 0);
*   #R145 @PLACE(y=0);
*   #R144 #R145 @DISTANCE("x", min=8, max=12);
*   #R146 @PLACE(1460, 0);
*   #R147 @PLACE(y=0);
*   #R146 #R147 @DISTANCE("x", min=8, max=12);
*   #R148 @PLACE(1480, 0);
*   #R149 @PLACE(y=0);
*   #R148 #R149 @DISTANCE("x", min=8, max=12);
*   #R150 @PLACE(1500, 0);
*   #R151 @PLACE(y=0);
*   #R150 #R151 @DISTANCE("x", min=8, max=12);
*   #R152 @PLACE(1520, 0);
*   #R153 @PLACE(y=0);
*   #R152 #R153 @DISTANCE("x", min=8, max=12);
*   #R154 @PLACE(1540, 0);
*   #R155 @PLACE(y=0);
*   #R154 #R155 @DISTANCE("x", min=8, max=12);
*   #R156 @PLACE(1560, 0);
*   #R157 @PLACE(y=0);
*   #R156 #R157 @DISTANCE("x", min=8, max=12);
*   #R158 @PLACE(1580, 0);
*   #R159 @PLACE(y=0);
*   #R158 #R159 @DISTANCE("x", min=8, max=12);
*   #R160 @PLACE(1600, 0);
*   #R161 @PLACE(y=0);
*   #R160 #R161 @DISTANCE("x", min=8, max=12);
*   #R162 @PLACE(1620, 0);
*   #R163 @PLACE(y=0);
*   #R162 #R163 @DISTANCE("x", min=8, max=12);
*   #R164 @PLACE(1640, 0);
*   #R165 @PLACE(y=0);
*   #R164 #R165 @DISTANCE("x", min=8, max=12);
*   #R166 @PLACE(1660, 0);
*   #R167 @PLACE(y=0);
*   #R166 #R167 @DISTANCE("x", min=8, max=12);
*   #R168 @PLACE(1680, 0);
*   #R169 @PLACE(y=0);
*   #R168 #R169 @DISTANCE("x", min=8, max=12);
*   #R170 @PLACE(1700, 0);
*   #R171 @PLACE(y=0);
*   #R170 #R171 @DISTANCE("x", min=8, max=12);
*   #R172 @PLACE(1720, 0);
*   #R173 @PLACE(y=0);
*   #R172 #R173 @DISTANCE("x", min=8, max=12);
*   #R174 @PLACE(1740, 0);
*   #R175 @PLACE(y=0);
*   #R174 #R175 @DISTANCE("x", min=8, max=12);
*   #R176 @PLACE(1760, 0);
*   #R177 @PLACE(y=0);
*   #R176 #R177 @DISTANCE("x", min=8, max=12);
*   #R178 @PLACE(1780, 0);
*   #R179 @PLACE(y=0);
*   #R178 #R179 @DISTANCE("x", min=8, max=12);
*   #R180 @PLACE(1800, 0);
*   #R181 @PLACE(y=0);
*   #R180 #R181 @DISTANCE("x", min=8, max=12);
*   #R182 @PLACE(1820, 0);
*   #R183 @PLACE(y=0);
*   #R182 #R183 @DISTANCE("x", min=8, max=12);
*   #R184 @PLACE(1840, 0);
*   #R185 @PLACE(y=0);
*   #R184 #R185 @DISTANCE("x", min=8, max=12);
*   #R186 @PLACE(1860, 0);
*   #R187 @PLACE(y=0);
*   #R186 #R187 @DISTANCE("x", min=8, max=12);
*   #R188 @PLACE(1880, 0);
*   #R189 @PLACE(y=0);
*   #R188 #R189 @DISTANCE("x", min=8, max=12);
*   #R190 @PLACE(1900, 0);
*   #R191 @PLACE(y=0);
*   #R190 #R191 @DISTANCE("x", min=8, max=12);
*   #R192 @PLACE(1920, 0);
*   #R193 @PLACE(y=0);
*   #R192 #R193 @DISTANCE("x", min=8, max=12);
*   #R194 @PLACE(1940, 0);
*   #R195 @PLACE(y=0);
*   #R194 #R195 @DISTANCE("x", min=8, max=12);
*   #R196 @PLACE(1960, 0);
*   #R197 @PLACE(y=0);
*   #R196 #R197 @DISTANCE("x", min=8, max=12);
*   #R198 @PLACE(1980, 0);
*   #R199 @PLACE(y=0);
*   #R198 #R199 @DISTANCE("x", min=8, max=12);
*   #R200 @PLACE(2000, 0);
*   #R201 @PLACE(y=0);
*   #R200 #R201 @DISTANCE("x", min=8, max=12);
*   #R202 @PLACE(2020, 0);
*   #R203 @PLACE(y=0);
*   #R202 #R203 @DISTANCE("x", min=8, max=12);
*   #R204 @PLACE(2040, 0);
*   #R205 @PLACE(y=0);
*   #R204 #R205 @DISTANCE("x", min=8, max=12);
*   #R206 @PLACE(2060, 0);
*   #R207 @PLACE(y=0);
*   #R206 #R207 @DISTANCE("x", min=8, max=12);
*   #R208 @PLACE(2080, 0);
*   #R209 @PLACE(y=0);
*   #R208 #R209 @DISTANCE("x", min=8, max=12);
*   #R210 @PLACE(2100, 0);
*   #R211 @PLACE(y=0);
*   #R210 #R211 @DISTANCE("x", min=8, max=12);
*   #R212 @PLACE(2120, 0);
*   #R213 @PLACE(y=0);
*   #R212 #R213 @DISTANCE("x", min=8, max=12);
*   #R214 @PLACE(2140, 0);
*   #R215 @PLACE(y=0);
*   #R214 #R215 @DISTANCE("x", min=8, max=12);
*   #R216 @PLACE(2160, 0);
*   #R217 @PLACE(y=0);
*   #R216 #R217 @DISTANCE("x", min=8, max=12);
*   #R218 @PLACE(2180, 0);
*   #R219 @PLACE(y=0);
*   #R218 #R219 @DISTANCE("x", min=8, max=12);
*   #R220 @PLACE(2200, 0);
*   #R221 @PLACE(y=0);
*   #R220 #R221 @DISTANCE("x", min=8, max=12);
*   #R222 @PLACE(2220, 0);
*   #R223 @PLACE(y=0);
*   #R222 #R223 @DISTANCE("x", min=8, max=12);
*   #R224 @PLACE(2240, 0);
*   #R225 @PLACE(y=0);
*   #R224 #R225 @DISTANCE("x", min=8, max=12);
*   #R226 @PLACE(2260, 0);
*   #R227 @PLACE(y=0);
*   #R226 #R227 @DISTANCE("x", min=8, max=12);
*   #R228 @PLACE(2280, 0);
*   #R229 @PLACE(y=0);
*   #R228 #R229 @DISTANCE("x", min=8, max=12);
*   #R230 @PLACE(2300, 0);
*   #R231 @PLACE(y=0);
*   #R230 #R231 @DISTANCE("x", min=8, max=12);
*   #R232 @PLACE(2320, 0);
*   #R233 @PLACE(y=0);
*   #R232 #R233 @DISTANCE("x", min=8, max=12);
*   #R234 @PLACE(2340, 0);
*   #R235 @PLACE(y=0);
*   #R234 #R235 @DISTANCE("x", min=8, max=12);
*   #R236 @PLACE(2360, 0);
*   #R237 @PLACE(y=0);
*   #R236 #R237 @DISTANCE("x", min=8, max=12);
*   #R238 @PLACE(2380, 0);
*   #R239 @PLACE(y=0);
*   #R238 #R239 @DISTANCE("x", min=8, max=12);
*   #R240 @PLACE(2400, 0);
*   #R241 @PLACE(y=0);
*   #R240 #R241 @DISTANCE("x", min=8, max=12);
*   #R242 @PLACE(2420, 0);
*   #R243 @PLACE(y=0);
*   #R242 #R243 @DISTANCE("x", min=8, max=12);
*   #R244 @PLACE(2440, 0);
*   #R245 @PLACE(y=0);
*   #R244 #R245 @DISTANCE("x", min=8, max=12);
*   #R246 @PLACE(2460, 0);
*   #R247 @PLACE(y=0);
*   #R246 #R247 @DISTANCE("x", min=8, max=12);
*   #R248 @PLACE(2480, 0);
*   #R249 @PLACE(y=0);
*   #R248 #R249 @DISTANCE("x", min=8, max=12);
*   #R250 @PLACE(2500, 0);
*   #R251 @PLACE(y=0);
*   #R250 #R251 @DISTANCE("x", min=8, max=12);
*   #R252 @PLACE(2520, 0);
*   #R253 @PLACE(y=0);
*   #R252 #R253 @DISTANCE("x", min=8, max=12);
*   #R254 @PLACE(2540, 0);
*   #R255 @PLACE(y=0);
*   #R254 #R255 @DISTANCE("x", min=8, max=12);
*   $WIRE_NET_SET @ROUTE
* }
.end
