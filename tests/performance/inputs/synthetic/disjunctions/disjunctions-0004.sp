* Synthetic disjunctions; n=4; generated by prepare_inputs.py
* @RNL(type="header") { @VERSION("0.3") }
R0 q0 q1 1k
R1 q1 q2 1k
R2 q2 q3 1k
R3 q3 q4 1k
R4 q4 q5 1k
R5 q5 q6 1k
R6 q6 q7 1k
R7 q7 q8 1k
* @RNL {
*   #R0 @PLACE(0, 0);
*   #R1 @PLACE(y=0);
*   #R0 #R1 @DISTANCE("x", min=8, max=12);
*   #R2 @PLACE(20, 0);
*   #R3 @PLACE(y=0);
*   #R2 #R3 @DISTANCE("x", min=8, max=12);
*   #R4 @PLACE(40, 0);
*   #R5 @PLACE(y=0);
*   #R4 #R5 @DISTANCE("x", min=8, max=12);
*   #R6 @PLACE(60, 0);
*   #R7 @PLACE(y=0);
*   #R6 #R7 @DISTANCE("x", min=8, max=12);
*   $WIRE_NET_SET @ROUTE
* }
.end
