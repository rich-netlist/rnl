* Synthetic disjunctions; n=64; generated by prepare_inputs.py
* @RNL(type="header") { @VERSION("0.3") }
R0 q0 q1 1k
R1 q1 q2 1k
R2 q2 q3 1k
R3 q3 q4 1k
R4 q4 q5 1k
R5 q5 q6 1k
R6 q6 q7 1k
R7 q7 q8 1k
R8 q8 q9 1k
R9 q9 q10 1k
R10 q10 q11 1k
R11 q11 q12 1k
R12 q12 q13 1k
R13 q13 q14 1k
R14 q14 q15 1k
R15 q15 q16 1k
R16 q16 q17 1k
R17 q17 q18 1k
R18 q18 q19 1k
R19 q19 q20 1k
R20 q20 q21 1k
R21 q21 q22 1k
R22 q22 q23 1k
R23 q23 q24 1k
R24 q24 q25 1k
R25 q25 q26 1k
R26 q26 q27 1k
R27 q27 q28 1k
R28 q28 q29 1k
R29 q29 q30 1k
R30 q30 q31 1k
R31 q31 q32 1k
R32 q32 q33 1k
R33 q33 q34 1k
R34 q34 q35 1k
R35 q35 q36 1k
R36 q36 q37 1k
R37 q37 q38 1k
R38 q38 q39 1k
R39 q39 q40 1k
R40 q40 q41 1k
R41 q41 q42 1k
R42 q42 q43 1k
R43 q43 q44 1k
R44 q44 q45 1k
R45 q45 q46 1k
R46 q46 q47 1k
R47 q47 q48 1k
R48 q48 q49 1k
R49 q49 q50 1k
R50 q50 q51 1k
R51 q51 q52 1k
R52 q52 q53 1k
R53 q53 q54 1k
R54 q54 q55 1k
R55 q55 q56 1k
R56 q56 q57 1k
R57 q57 q58 1k
R58 q58 q59 1k
R59 q59 q60 1k
R60 q60 q61 1k
R61 q61 q62 1k
R62 q62 q63 1k
R63 q63 q64 1k
R64 q64 q65 1k
R65 q65 q66 1k
R66 q66 q67 1k
R67 q67 q68 1k
R68 q68 q69 1k
R69 q69 q70 1k
R70 q70 q71 1k
R71 q71 q72 1k
R72 q72 q73 1k
R73 q73 q74 1k
R74 q74 q75 1k
R75 q75 q76 1k
R76 q76 q77 1k
R77 q77 q78 1k
R78 q78 q79 1k
R79 q79 q80 1k
R80 q80 q81 1k
R81 q81 q82 1k
R82 q82 q83 1k
R83 q83 q84 1k
R84 q84 q85 1k
R85 q85 q86 1k
R86 q86 q87 1k
R87 q87 q88 1k
R88 q88 q89 1k
R89 q89 q90 1k
R90 q90 q91 1k
R91 q91 q92 1k
R92 q92 q93 1k
R93 q93 q94 1k
R94 q94 q95 1k
R95 q95 q96 1k
R96 q96 q97 1k
R97 q97 q98 1k
R98 q98 q99 1k
R99 q99 q100 1k
R100 q100 q101 1k
R101 q101 q102 1k
R102 q102 q103 1k
R103 q103 q104 1k
R104 q104 q105 1k
R105 q105 q106 1k
R106 q106 q107 1k
R107 q107 q108 1k
R108 q108 q109 1k
R109 q109 q110 1k
R110 q110 q111 1k
R111 q111 q112 1k
R112 q112 q113 1k
R113 q113 q114 1k
R114 q114 q115 1k
R115 q115 q116 1k
R116 q116 q117 1k
R117 q117 q118 1k
R118 q118 q119 1k
R119 q119 q120 1k
R120 q120 q121 1k
R121 q121 q122 1k
R122 q122 q123 1k
R123 q123 q124 1k
R124 q124 q125 1k
R125 q125 q126 1k
R126 q126 q127 1k
R127 q127 q128 1k
* @RNL {
*   #R0 @PLACE(0, 0);
*   #R1 @PLACE(y=0);
*   #R0 #R1 @DISTANCE("x", min=8, max=12);
*   #R2 @PLACE(20, 0);
*   #R3 @PLACE(y=0);
*   #R2 #R3 @DISTANCE("x", min=8, max=12);
*   #R4 @PLACE(40, 0);
*   #R5 @PLACE(y=0);
*   #R4 #R5 @DISTANCE("x", min=8, max=12);
*   #R6 @PLACE(60, 0);
*   #R7 @PLACE(y=0);
*   #R6 #R7 @DISTANCE("x", min=8, max=12);
*   #R8 @PLACE(80, 0);
*   #R9 @PLACE(y=0);
*   #R8 #R9 @DISTANCE("x", min=8, max=12);
*   #R10 @PLACE(100, 0);
*   #R11 @PLACE(y=0);
*   #R10 #R11 @DISTANCE("x", min=8, max=12);
*   #R12 @PLACE(120, 0);
*   #R13 @PLACE(y=0);
*   #R12 #R13 @DISTANCE("x", min=8, max=12);
*   #R14 @PLACE(140, 0);
*   #R15 @PLACE(y=0);
*   #R14 #R15 @DISTANCE("x", min=8, max=12);
*   #R16 @PLACE(160, 0);
*   #R17 @PLACE(y=0);
*   #R16 #R17 @DISTANCE("x", min=8, max=12);
*   #R18 @PLACE(180, 0);
*   #R19 @PLACE(y=0);
*   #R18 #R19 @DISTANCE("x", min=8, max=12);
*   #R20 @PLACE(200, 0);
*   #R21 @PLACE(y=0);
*   #R20 #R21 @DISTANCE("x", min=8, max=12);
*   #R22 @PLACE(220, 0);
*   #R23 @PLACE(y=0);
*   #R22 #R23 @DISTANCE("x", min=8, max=12);
*   #R24 @PLACE(240, 0);
*   #R25 @PLACE(y=0);
*   #R24 #R25 @DISTANCE("x", min=8, max=12);
*   #R26 @PLACE(260, 0);
*   #R27 @PLACE(y=0);
*   #R26 #R27 @DISTANCE("x", min=8, max=12);
*   #R28 @PLACE(280, 0);
*   #R29 @PLACE(y=0);
*   #R28 #R29 @DISTANCE("x", min=8, max=12);
*   #R30 @PLACE(300, 0);
*   #R31 @PLACE(y=0);
*   #R30 #R31 @DISTANCE("x", min=8, max=12);
*   #R32 @PLACE(320, 0);
*   #R33 @PLACE(y=0);
*   #R32 #R33 @DISTANCE("x", min=8, max=12);
*   #R34 @PLACE(340, 0);
*   #R35 @PLACE(y=0);
*   #R34 #R35 @DISTANCE("x", min=8, max=12);
*   #R36 @PLACE(360, 0);
*   #R37 @PLACE(y=0);
*   #R36 #R37 @DISTANCE("x", min=8, max=12);
*   #R38 @PLACE(380, 0);
*   #R39 @PLACE(y=0);
*   #R38 #R39 @DISTANCE("x", min=8, max=12);
*   #R40 @PLACE(400, 0);
*   #R41 @PLACE(y=0);
*   #R40 #R41 @DISTANCE("x", min=8, max=12);
*   #R42 @PLACE(420, 0);
*   #R43 @PLACE(y=0);
*   #R42 #R43 @DISTANCE("x", min=8, max=12);
*   #R44 @PLACE(440, 0);
*   #R45 @PLACE(y=0);
*   #R44 #R45 @DISTANCE("x", min=8, max=12);
*   #R46 @PLACE(460, 0);
*   #R47 @PLACE(y=0);
*   #R46 #R47 @DISTANCE("x", min=8, max=12);
*   #R48 @PLACE(480, 0);
*   #R49 @PLACE(y=0);
*   #R48 #R49 @DISTANCE("x", min=8, max=12);
*   #R50 @PLACE(500, 0);
*   #R51 @PLACE(y=0);
*   #R50 #R51 @DISTANCE("x", min=8, max=12);
*   #R52 @PLACE(520, 0);
*   #R53 @PLACE(y=0);
*   #R52 #R53 @DISTANCE("x", min=8, max=12);
*   #R54 @PLACE(540, 0);
*   #R55 @PLACE(y=0);
*   #R54 #R55 @DISTANCE("x", min=8, max=12);
*   #R56 @PLACE(560, 0);
*   #R57 @PLACE(y=0);
*   #R56 #R57 @DISTANCE("x", min=8, max=12);
*   #R58 @PLACE(580, 0);
*   #R59 @PLACE(y=0);
*   #R58 #R59 @DISTANCE("x", min=8, max=12);
*   #R60 @PLACE(600, 0);
*   #R61 @PLACE(y=0);
*   #R60 #R61 @DISTANCE("x", min=8, max=12);
*   #R62 @PLACE(620, 0);
*   #R63 @PLACE(y=0);
*   #R62 #R63 @DISTANCE("x", min=8, max=12);
*   #R64 @PLACE(640, 0);
*   #R65 @PLACE(y=0);
*   #R64 #R65 @DISTANCE("x", min=8, max=12);
*   #R66 @PLACE(660, 0);
*   #R67 @PLACE(y=0);
*   #R66 #R67 @DISTANCE("x", min=8, max=12);
*   #R68 @PLACE(680, 0);
*   #R69 @PLACE(y=0);
*   #R68 #R69 @DISTANCE("x", min=8, max=12);
*   #R70 @PLACE(700, 0);
*   #R71 @PLACE(y=0);
*   #R70 #R71 @DISTANCE("x", min=8, max=12);
*   #R72 @PLACE(720, 0);
*   #R73 @PLACE(y=0);
*   #R72 #R73 @DISTANCE("x", min=8, max=12);
*   #R74 @PLACE(740, 0);
*   #R75 @PLACE(y=0);
*   #R74 #R75 @DISTANCE("x", min=8, max=12);
*   #R76 @PLACE(760, 0);
*   #R77 @PLACE(y=0);
*   #R76 #R77 @DISTANCE("x", min=8, max=12);
*   #R78 @PLACE(780, 0);
*   #R79 @PLACE(y=0);
*   #R78 #R79 @DISTANCE("x", min=8, max=12);
*   #R80 @PLACE(800, 0);
*   #R81 @PLACE(y=0);
*   #R80 #R81 @DISTANCE("x", min=8, max=12);
*   #R82 @PLACE(820, 0);
*   #R83 @PLACE(y=0);
*   #R82 #R83 @DISTANCE("x", min=8, max=12);
*   #R84 @PLACE(840, 0);
*   #R85 @PLACE(y=0);
*   #R84 #R85 @DISTANCE("x", min=8, max=12);
*   #R86 @PLACE(860, 0);
*   #R87 @PLACE(y=0);
*   #R86 #R87 @DISTANCE("x", min=8, max=12);
*   #R88 @PLACE(880, 0);
*   #R89 @PLACE(y=0);
*   #R88 #R89 @DISTANCE("x", min=8, max=12);
*   #R90 @PLACE(900, 0);
*   #R91 @PLACE(y=0);
*   #R90 #R91 @DISTANCE("x", min=8, max=12);
*   #R92 @PLACE(920, 0);
*   #R93 @PLACE(y=0);
*   #R92 #R93 @DISTANCE("x", min=8, max=12);
*   #R94 @PLACE(940, 0);
*   #R95 @PLACE(y=0);
*   #R94 #R95 @DISTANCE("x", min=8, max=12);
*   #R96 @PLACE(960, 0);
*   #R97 @PLACE(y=0);
*   #R96 #R97 @DISTANCE("x", min=8, max=12);
*   #R98 @PLACE(980, 0);
*   #R99 @PLACE(y=0);
*   #R98 #R99 @DISTANCE("x", min=8, max=12);
*   #R100 @PLACE(1000, 0);
*   #R101 @PLACE(y=0);
*   #R100 #R101 @DISTANCE("x", min=8, max=12);
*   #R102 @PLACE(1020, 0);
*   #R103 @PLACE(y=0);
*   #R102 #R103 @DISTANCE("x", min=8, max=12);
*   #R104 @PLACE(1040, 0);
*   #R105 @PLACE(y=0);
*   #R104 #R105 @DISTANCE("x", min=8, max=12);
*   #R106 @PLACE(1060, 0);
*   #R107 @PLACE(y=0);
*   #R106 #R107 @DISTANCE("x", min=8, max=12);
*   #R108 @PLACE(1080, 0);
*   #R109 @PLACE(y=0);
*   #R108 #R109 @DISTANCE("x", min=8, max=12);
*   #R110 @PLACE(1100, 0);
*   #R111 @PLACE(y=0);
*   #R110 #R111 @DISTANCE("x", min=8, max=12);
*   #R112 @PLACE(1120, 0);
*   #R113 @PLACE(y=0);
*   #R112 #R113 @DISTANCE("x", min=8, max=12);
*   #R114 @PLACE(1140, 0);
*   #R115 @PLACE(y=0);
*   #R114 #R115 @DISTANCE("x", min=8, max=12);
*   #R116 @PLACE(1160, 0);
*   #R117 @PLACE(y=0);
*   #R116 #R117 @DISTANCE("x", min=8, max=12);
*   #R118 @PLACE(1180, 0);
*   #R119 @PLACE(y=0);
*   #R118 #R119 @DISTANCE("x", min=8, max=12);
*   #R120 @PLACE(1200, 0);
*   #R121 @PLACE(y=0);
*   #R120 #R121 @DISTANCE("x", min=8, max=12);
*   #R122 @PLACE(1220, 0);
*   #R123 @PLACE(y=0);
*   #R122 #R123 @DISTANCE("x", min=8, max=12);
*   #R124 @PLACE(1240, 0);
*   #R125 @PLACE(y=0);
*   #R124 #R125 @DISTANCE("x", min=8, max=12);
*   #R126 @PLACE(1260, 0);
*   #R127 @PLACE(y=0);
*   #R126 #R127 @DISTANCE("x", min=8, max=12);
*   $WIRE_NET_SET @ROUTE
* }
.end
