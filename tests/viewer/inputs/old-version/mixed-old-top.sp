* A netlist of RNL 0.3 that includes a file of a later version
* @RNL(type="header") { @VERSION("0.3") }
.include "cell-0.5.inc"
X1 in out cell
.end
