* An RC low-pass filter written in RNL 0.3, which this viewer does not read
* @RNL(type="header") { @VERSION("0.3") }
V1 in 0 1
R1 in out 1k
C1 out 0 1n
* @RNL { #V1 @PLACE(0, 0); #R1 @PLACE(4, 2); #C1 @PLACE(8, 0) }
.end
