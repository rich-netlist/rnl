* A netlist of RNL 0.4 that includes a library written in RNL 0.3
.include "cells-0.3.inc"
V1 in 0 1
X1 in out rdiv
* @RNL { #V1 @PLACE(0, 0); #X1 @PLACE(6, 0) }
.end
