* two definitions of adc_ref in the Library
X1 in out adc_ref
X2 in out adc_ref
XO in out other
R1 in out 1k
.end
