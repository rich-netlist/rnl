* Fold definitions in selected and unselected library sections
.lib "fold-sections.inc" active
.include "fold-models.inc"
X1 a 0 active_cell
.end
