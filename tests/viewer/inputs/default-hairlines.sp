* Renderer defaults without a library stylesheet (--no-std)
* @RNL(type="header") { @VERSION("0.4") }
* @RNL {
*   @LINE {(0, -4) (20, -4)};
*   @LINE(linewidth=0) {(0, -7) (20, -7)};
*   @LINE(linewidth=0.2) {(0, -10) (20, -10)};
*   @LINE(linewidth=0, linestyle="double") {(0, -13) (20, -13)}
* }
.end
