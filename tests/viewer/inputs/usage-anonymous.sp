* Anonymous semantic usage
* @RNL(type="header") { @USE-PACKAGE(name="rnl-std-all", version="0.4"); @VERSION("0.4") }
* @RNL { /* rnl upgrade wrote this record: it keeps the labels and ports the file had before 0.4 */ # @SELECT-PIN(recursive=true) => @REMOVE-FROM $LABEL_FILL_SET; $SUPPLY_NET_SET @REMOVE-FROM $PORT_FILL_SET; $GROUND_NET_SET @REMOVE-FROM $PORT_FILL_SET }
R1 a b 1k
R2 b c 2k
* Source navigation padding 0
* Source navigation padding 1
* Source navigation padding 2
* Source navigation padding 3
* Source navigation padding 4
* Source navigation padding 5
* Source navigation padding 6
* Source navigation padding 7
* Source navigation padding 8
* Source navigation padding 9
* Source navigation padding 10
* Source navigation padding 11
* Source navigation padding 12
* Source navigation padding 13
* Source navigation padding 14
* Source navigation padding 15
* Source navigation padding 16
* Source navigation padding 17
* Source navigation padding 18
* Source navigation padding 19
* Source navigation padding 20
* Source navigation padding 21
* Source navigation padding 22
* Source navigation padding 23
* Source navigation padding 24
* Source navigation padding 25
* Source navigation padding 26
* Source navigation padding 27
* Source navigation padding 28
* Source navigation padding 29
* Source navigation padding 30
* Source navigation padding 31
* Source navigation padding 32
* Source navigation padding 33
* Source navigation padding 34
* Source navigation padding 35
* Source navigation padding 36
* Source navigation padding 37
* Source navigation padding 38
* Source navigation padding 39
* Source navigation padding 40
* Source navigation padding 41
* Source navigation padding 42
* Source navigation padding 43
* Source navigation padding 44
* Source navigation padding 45
* Source navigation padding 46
* Source navigation padding 47
* Source navigation padding 48
* Source navigation padding 49
* Source navigation padding 50
* Source navigation padding 51
* Source navigation padding 52
* Source navigation padding 53
* Source navigation padding 54
* Source navigation padding 55
* Source navigation padding 56
* Source navigation padding 57
* Source navigation padding 58
* Source navigation padding 59
* @RNL {
*   $PAIR = @DEFINE(roles=["left", "right"]) {};
*   #R1 @PLACE(0, 0); #R2 @PLACE(10, 0);
*   #R1(left) #R2(right) @AS $PAIR
* }
.end
