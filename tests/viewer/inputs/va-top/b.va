module amp(inp, outp);
  inout inp, outp;
  electrical inp, outp;
endmodule
