* stage: an instance of amp, which cells/amp.sp defines, without an include: Auto Include finds it
.subckt stage in out
X1 in out amp
.ends stage
